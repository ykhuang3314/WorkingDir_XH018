ADE simulation setup
Run mode: Single Run, Sweeps and Corners
Tests:
  MultiChannel_EMG_TestBench:TCA_DSL_TB:1: MultiChannel_EMG_TestBench/TCA_DSL_TB/schematic, simulator spectre
Global variables:
  Rint = 16G
  AMP_input = 100u
  freq_input = 500
  VOS = 0
