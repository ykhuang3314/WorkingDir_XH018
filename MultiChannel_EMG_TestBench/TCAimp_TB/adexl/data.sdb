ADE simulation setup
Run mode: Single Run, Sweeps and Corners
Tests:
  MultiChannel_EMG_TestBench:TCAimp_TB:1: MultiChannel_EMG_TestBench/TCAimp_TB/schematic, simulator spectre
Global variables:
  VCM = 900m
  VCM_AC = 0
  VOS = 0
  AMP = 100u
  VIN_AC = 0
  fsig = 40k
