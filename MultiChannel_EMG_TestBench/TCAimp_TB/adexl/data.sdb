ADE simulation setup
Run mode: Single Run, Sweeps and Corners
Tests:
  MultiChannel_EMG_TestBench:TCAimp_TB:1: MultiChannel_EMG_TestBench/TCAimp_TB/schematic, simulator spectre
    Outputs: Input Referred Noise
Global variables:
  VCM = 900m
  VCM_AC = 0
  VOS = 0
  AMP = 0
  VIN_AC = 1
  fsig = 500
  IPULSE_BIAS = 0
  VD_PULSE = 0
  VDD = 1.8
  VDD_AC = 0
  VIN_PULSE = 1m
  VDC_IN = 0
Corners:
  model folders: /pkg/xfab/XKIT/xh018/cadence/v8_0/spectre/v8_0_1/lpmos
  C1: param.scs[3s], bip.scs[tm], cap.scs[wp ws], dio.scs[tm], mos.scs[wo wp ws wz], photo.scs[tm], res.scs[wp ws]
