ADE simulation setup
Run mode: Single Run, Sweeps and Corners
Tests:
  MultiChannel_EMG_TestBench:MultiChannelAFE_TB:1: MultiChannel_EMG_TestBench/MultiChannelAFE_TB/config, simulator ams
    Outputs: VIN_Diff_CH1; ChopOUT_Diff_CH1; TCAOUT_Diff_CH1; VIN_Diff_CH2; ChopOUT_Diff_CH2; TCAOUT_Diff_CH2; MixedOUT_Diff; VoutTIA_Diff; deModOut_Diff_CH2; LPFOUT_Diff_CH2
Global variables:
  AMP = 100u
  fsig = 300
  VCM = 900m
  VCM_AC = 0
  VIN_AC = 1
  VOS = 0
