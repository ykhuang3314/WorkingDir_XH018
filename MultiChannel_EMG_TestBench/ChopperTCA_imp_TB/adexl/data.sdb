ADE simulation setup
Run mode: Single Run, Sweeps and Corners
Tests:
  MultiChannel_EMG_TestBench:ChopperTCA_imp_TB:1: MultiChannel_EMG_TestBench/ChopperTCA_imp_TB/config, simulator ams
    Outputs: /deModOUTP; /deModOUTN; deModOUT_Diff; IOUT_TCA_Diff; VOUT_TIA
Global variables:
  AMP = 100u
  fchop = 16k
  fsig = 300
  VCM = 900m
  VCM_AC = 0
  VIN_AC = 0
  VOS = 0
