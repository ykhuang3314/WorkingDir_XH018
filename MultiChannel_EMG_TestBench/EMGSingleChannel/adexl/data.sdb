ADE simulation setup
Run mode: Single Run, Sweeps and Corners
Tests:
  MultiChannel_EMG_TestBench:EMGSingleChannel:1: MultiChannel_EMG_TestBench/EMGSingleChannel/config, simulator ams
Global variables:
  fsample = 100k
  fchop = 16k
  fin = 500
  Mag = 1e-3
  Vin_cm = 0
  Voffset = 0
