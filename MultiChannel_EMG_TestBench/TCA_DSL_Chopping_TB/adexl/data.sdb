ADE simulation setup
Run mode: Single Run, Sweeps and Corners
Tests:
  MultiChannel_EMG_TestBench:TCA_DSL_Chopping_TB:1: MultiChannel_EMG_TestBench/TCA_DSL_Chopping_TB/config, simulator ams
    Outputs: Iout_DSL_TCA_diff
Global variables:
  Amp_input = 1m
  CM_DC = 0.9
  Freq_input = 500
  Vos = 50m
  Fchop = 16
