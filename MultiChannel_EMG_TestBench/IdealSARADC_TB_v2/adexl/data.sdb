ADE simulation setup
Run mode: Single Run, Sweeps and Corners
Tests:
  MultiChannel_EMG_TestBench:IdealSARADC_TB_v2:1: MultiChannel_EMG_TestBench/IdealSARADC_TB_v2/config, simulator ams
Global variables:
  fsample = 100k
