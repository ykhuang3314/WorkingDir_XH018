ADE simulation setup
Run mode: Single Run, Sweeps and Corners
Tests:
  MultiChannel_EMG_TestBench:IdealADC_TB:1: MultiChannel_EMG_TestBench/IdealADC_TB/config, simulator ams
Global variables:
  fsample = 100K
