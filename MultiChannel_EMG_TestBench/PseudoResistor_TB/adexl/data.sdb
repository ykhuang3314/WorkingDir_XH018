ADE simulation setup
Run mode: Single Run, Sweeps and Corners
Tests:
  MultiChannel_EMG_TestBench:PseudoResistor_TB:1: MultiChannel_EMG_TestBench/PseudoResistor_TB/schematic, simulator spectre
Global variables:
  Lp2 = 2u
  Wp2 = 9u
  deltaV = 0
  Lp = 2u
  VA = 900m
  Wp = 3u
Corners:
  model folders: /pkg/xfab/XKIT/xh018/cadence/v8_0/spectre/v8_0_1/lpmos
  C0: param.scs[3s], bip.scs[tm], cap.scs[wp ws], dio.scs[wp ws], mos.scs[wo wp ws wz], photo.scs[tm], res.scs[wp ws]
