ADE simulation setup
Run mode: Single Run, Sweeps and Corners
Tests:
  MultiChannel_EMG_TestBench:MultiChannelAFE_TB_2:1: MultiChannel_EMG_TestBench/MultiChannelAFE_TB_2/config, simulator ams
    Outputs: Vin_diff_ch1; Vin_diff_ch2; /CLK1; /CLK2
Global variables:
  AMP = 1m
  fsig = 500
  VCM = 900m
  VCM_AC = 0
  VIN_AC = 0
  VOS = 50m
