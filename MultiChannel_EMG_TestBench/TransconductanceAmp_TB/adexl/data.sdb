ADE simulation setup
Run mode: Single Run, Sweeps and Corners
Tests:
  MultiChannel_EMG_TestBench:TransconductanceAmp_TB:1: MultiChannel_EMG_TestBench/TransconductanceAmp_TB/config, simulator ams
    Outputs: /IP; /IPRB1/PLUS
Global variables:
  fin = 500m
  Mag = 100u
  Vin_cm = 900m
  Voffset = 0
