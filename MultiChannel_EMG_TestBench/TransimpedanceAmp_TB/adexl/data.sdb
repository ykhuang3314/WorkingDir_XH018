ADE simulation setup
Run mode: Single Run, Sweeps and Corners
Tests:
  MultiChannel_EMG_TestBench:TransimpedanceAmp_TB:1: MultiChannel_EMG_TestBench/TransimpedanceAmp_TB/config, simulator ams
Global variables:
  Idc = 0
  AMP = 100n
  fsig = 16k
  MagAC = 1
