// Design: MultiChannel_EMG_TestBench/PseudoResistor_TB
simulator lang=spectre
global 0
parameters Lp2=1u Wp2=6u deltaV=0 Lp=500n VA=900m Wp=1.5u
include "/pkg/xfab/XKIT/xh018/cadence/v8_0/spectre/v8_0_1/lpmos/config.scs" section=default
include "/pkg/xfab/XKIT/xh018/cadence/v8_0/spectre/v8_0_1/lpmos/param.scs" section=3s
include "/pkg/xfab/XKIT/xh018/cadence/v8_0/spectre/v8_0_1/lpmos/bip.scs" section=tm
include "/pkg/xfab/XKIT/xh018/cadence/v8_0/spectre/v8_0_1/lpmos/cap.scs" section=tm
include "/pkg/xfab/XKIT/xh018/cadence/v8_0/spectre/v8_0_1/lpmos/dio.scs" section=tm
include "/pkg/xfab/XKIT/xh018/cadence/v8_0/spectre/v8_0_1/lpmos/mos.scs" section=tm
include "/pkg/xfab/XKIT/xh018/cadence/v8_0/spectre/v8_0_1/lpmos/photo.scs" section=tm
include "/pkg/xfab/XKIT/xh018/cadence/v8_0/spectre/v8_0_1/lpmos/res.scs" section=tm

// MultiChannel_EMG_TestBench/PseudoResistor_TB/schematic
M11 (net015 net015 net011 net015) pel w=Wp2 l=Lp2 m=(1)*(1)
M10 (net015 net015 net014 net015) pel w=Wp2 l=Lp2 m=(1)*(1)
M7 (net09 net09 net018 net09) pel w=Wp2 l=Lp2 m=(1)*(1)
M6 (net027 net027 net020 net027) pel w=Wp2 l=Lp2 m=(1)*(1)
M5 (net08 net08 net027 net027) pel w=Wp l=Lp m=(1)*(1)
M4 (net08 net08 net09 net09) pel w=Wp l=Lp m=(1)*(1)
M1 (net6 net6 net01 net01) pel w=Wp l=Lp m=(1)*(1)
M0 (net6 net6 net04 net04) pel w=Wp l=Lp m=(1)*(1)
V6 (net018 0) vsource dc=VA type=dc
V5 (net029 0) vsource dc=VA+deltaV type=dc
V4 (net011 0) vsource dc=VA type=dc
V3 (net07 0) vsource dc=VA+deltaV type=dc
V0 (net05 0) vsource dc=VA+deltaV type=dc
V1 (net04 0) vsource dc=VA type=dc
IPRB2 (net029 net020) iprobe
IPRB1 (net07 net014) iprobe
IPRB0 (net05 net01) iprobe
simulatorOptions options reltol=100e-6 temp=27 homotopy=all limit=delta compatible=spice2
dcOp dc
dc dc param=deltaV start=-400m stop=400m
save IPRB0:in IPRB2:in IPRB1:in
