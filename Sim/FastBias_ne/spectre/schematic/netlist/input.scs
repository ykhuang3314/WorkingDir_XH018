// Design: Device_Characteristics/FastBias_ne
simulator lang=spectre
global 0
parameters WF5=3.75e-07 L5=1.5e-05 NF5=1 IDS5=1e-07 VDS5=0.5 WF4=2e-06 L4=1e-06 NF4=10 IDS4=5e-07 VDS4=0.5 WF3=5e-07 L3=1.5e-05 NF3=10 IDS3=5e-06 VDS3=0.3 WF2=2e-05 L2=1e-05 NF2=1 IDS2=5e-08 VDS2=0.5 WF1=5e-07 L1=1.2e-05 NF1=10 IDS1=2e-06 VDS1=0.5
include "/pkg/xfab/XKIT/xh018/cadence/v8_0/spectre/v8_0_1/lpmos/config.scs" section=default
include "/pkg/xfab/XKIT/xh018/cadence/v8_0/spectre/v8_0_1/lpmos/param.scs" section=3s
include "/pkg/xfab/XKIT/xh018/cadence/v8_0/spectre/v8_0_1/lpmos/bip.scs" section=tm
include "/pkg/xfab/XKIT/xh018/cadence/v8_0/spectre/v8_0_1/lpmos/cap.scs" section=tm
include "/pkg/xfab/XKIT/xh018/cadence/v8_0/spectre/v8_0_1/lpmos/dio.scs" section=tm
include "/pkg/xfab/XKIT/xh018/cadence/v8_0/spectre/v8_0_1/lpmos/mos.scs" section=tm
include "/pkg/xfab/XKIT/xh018/cadence/v8_0/spectre/v8_0_1/lpmos/photo.scs" section=tm
include "/pkg/xfab/XKIT/xh018/cadence/v8_0/spectre/v8_0_1/lpmos/res.scs" section=tm

// Device_Characteristics/Bias_ne/schematic
subckt Bias_ne
parameters W L NF IDS VDS
    M0 (D G 0 0) ne w=W l=L m=(1)*(NF)
    I0 (0 D) isource dc=IDS type=dc
    E0 (G 0 D net7) vcvs gain=1000
    V0 (net7 0) vsource dc=VDS type=dc
ends Bias_ne

// Device_Characteristics/FastBias_ne/schematic
I4 Bias_ne W=WF5 L=L5 NF=NF5 IDS=IDS5 VDS=VDS5
I3 Bias_ne W=WF4 L=L4 NF=NF4 IDS=IDS4 VDS=VDS4
I2 Bias_ne W=WF3 L=L3 NF=NF3 IDS=IDS3 VDS=VDS3
I1 Bias_ne W=WF2 L=L2 NF=NF2 IDS=IDS2 VDS=VDS2
I0 Bias_ne W=WF1 L=L1 NF=NF1 IDS=IDS1 VDS=VDS1
simulatorOptions options reltol=100e-6 temp=27 homotopy=all limit=delta compatible=spice2
dcOp dc
