// AMS netlist generated by the AMS Unified netlister
// IC subversion:  IC6.1.8-64b.500.7
// Xcelium version: 18.03-s018
// Copyright(C) 2005-2009, Cadence Design Systems, Inc
// User: ykhuang Pid: 7925
// Design library name: MultiChannel_EMG_TestBench
// Design cell name: TCA_DSL_Chopping_TB
// Design view name: config
// Solver: Spectre

`include "disciplines.vams"
`include "userDisciplines.vams"
// HDL file - MultiChannel_EMG_Model, ClockGen, functional.
// Library - MultiChannel_EMG_TestBench, Cell - TCA_DSL_Chopping_TB, View - schematic
// LAST TIME SAVED: Oct  8 15:50:55 2021
// NETLIST TIME: Oct  8 15:51:09 2021

`worklib MultiChannel_EMG_TestBench
`view schematic

`timescale 1ns / 1ps
(* cds_ams_schematic *)

module TCA_DSL_Chopping_TB ( );
wire I_DSLn;
wire I_DSLp;
wire VSn;
wire VSp;
wire CLK;
wire CLKB;
wire net074;
wire net070;
wire net086;
wire net089;
wire Vinn;
wire Vinp;
wire LPFoutn;
wire net036;
wire net020;
wire LPFoutp;
Chopper I40 (.VSSA(cds_globals.\gnd! ), .CLKB( CLKB ), .CLK( CLK ), .OUTP( VSp ), .OUTN( VSn ), .INP( I_DSLp ), .INN( I_DSLn ));
Chopper I37 (.VSSA(cds_globals.\gnd! ), .CLKB( CLKB ), .CLK( CLK ), .OUTP( net070 ), .OUTN( net074 ), .INP( VSp ), .INN( VSn ));
Chopper I36 (.VSSA(cds_globals.\gnd! ), .CLKB( CLKB ), .CLK( CLK ), .OUTP( Vinp ), .OUTN( Vinn ), .INP( net089 ), .INN( net086 ));
PseudoResistor_45GOhm I35 (.B( net036 ), .A( LPFoutn ));
PseudoResistor_45GOhm I34 (.B( LPFoutp ), .A( net020 ));
ClockGen I28 (.CLK( CLK ), .CLKB( CLKB ));
capacitor #(.c(5e-12)) C9 (net074, cds_globals.\gnd! );
capacitor #(.c(5e-12)) C8 (net070, cds_globals.\gnd! );
capacitor #(.c(5e-12)) C7 (net061, cds_globals.\gnd! );
capacitor #(.c(5e-12)) C6 (net08, cds_globals.\gnd! );
capacitor #(.c(5e-12)) C5 (net04, cds_globals.\gnd! );
capacitor #(.c(5e-12)) C4 (net025, cds_globals.\gnd! );
capacitor #(.c(5e-12)) C3 (net067, cds_globals.\gnd! );
capacitor #(.c(5e-12)) C0 (LPFoutp, LPFoutn);
neli #(.w(2e-05), .l(5e-07), .as(9.6e-12), .ad(5.4e-12), .ps(4.096e-05), .pd(2.054e-05), .nrs(0.0135), .nrd(0.0135), .m((1)*(2)), .par1((1)*(2)))
(* integer passed_mfactor = "m"; *)
 M24 (net025, LPFoutn, net073, net073);
neli #(.w(2e-05), .l(5e-07), .as(9.6e-12), .ad(5.4e-12), .ps(4.096e-05), .pd(2.054e-05), .nrs(0.0135), .nrd(0.0135), .m((1)*(2)), .par1((1)*(2)))
(* integer passed_mfactor = "m"; *)
 M23 (net067, LPFoutp, net062, net062);
neli #(.w(4e-06), .l(1e-06), .as(1.248e-12), .ad(1.08e-12), .ps(5.424e-06), .pd(4.54e-06), .nrs(0.0675), .nrd(0.0675), .m((1)*(10)), .par1((1)*(10)))
(* integer passed_mfactor = "m"; *)
 M9 (VDDA, net074, net036, net036);
neli #(.w(4e-06), .l(1e-06), .as(1.248e-12), .ad(1.08e-12), .ps(5.424e-06), .pd(4.54e-06), .nrs(0.0675), .nrd(0.0675), .m((1)*(10)), .par1((1)*(10)))
(* integer passed_mfactor = "m"; *)
 M8 (VDDA, net070, net020, net020);
vsource #(.dc(cds_globals.Vos), .type("dc")) V6 (net029, VCM);
vsource #(.dc(cds_globals.CM_DC), .type("dc")) V2 (VCM, cds_globals.\gnd! );
vsource #(.dc(1.8), .type("dc")) V4 (VDDA, cds_globals.\gnd! );
isource #(.dc(5e-08), .type("dc")) I24 (VDDA, net06);
vsource #(.mag(0.5), .type("sine"), .ampl(cds_globals.Amp_input/2), .freq(cds_globals.Freq_input)) V1 (VCM, net086);
vsource #(.mag(0.5), .type("sine"), .ampl(cds_globals.Amp_input/2), .freq(cds_globals.Freq_input)) V0 (net089, net029);
pel #(.w(5e-06), .l(1e-05), .as(2.4e-12), .ad(2.4e-12), .ps(1.096e-05), .pd(1.096e-05), .nrs(0.054), .nrd(0.054), .m((1)*(1)), .par1((1)*(1)))
(* integer passed_mfactor = "m"; *)
 M28 (net073, net025, VDDA, VDDA);
pel #(.w(2e-06), .l(1e-05), .as(9.6e-13), .ad(9.6e-13), .ps(4.96e-06), .pd(4.96e-06), .nrs(0.135), .nrd(0.135), .m((1)*(1)), .par1((1)*(1)))
(* integer passed_mfactor = "m"; *)
 M46 (net025, net08, VDDA, VDDA);
pel #(.w(5e-06), .l(1e-05), .as(2.4e-12), .ad(2.4e-12), .ps(1.096e-05), .pd(1.096e-05), .nrs(0.054), .nrd(0.054), .m((1)*(1)), .par1((1)*(1)))
(* integer passed_mfactor = "m"; *)
 M27 (net062, net067, VDDA, VDDA);
pel #(.w(2e-06), .l(1e-05), .as(9.6e-13), .ad(9.6e-13), .ps(4.96e-06), .pd(4.96e-06), .nrs(0.135), .nrd(0.135), .m((1)*(1)), .par1((1)*(1)))
(* integer passed_mfactor = "m"; *)
 M45 (net067, net08, VDDA, VDDA);
pel #(.w(1e-05), .l(5e-07), .as(4.8e-12), .ad(4.8e-12), .ps(2.096e-05), .pd(2.096e-05), .nrs(0.027), .nrd(0.027), .m((1)*(1)), .par1((1)*(1)))
(* integer passed_mfactor = "m"; *)
 M41 (net8, net8, net054, net054);
pel #(.w(2e-06), .l(1e-05), .as(6.24e-13), .ad(5.4e-13), .ps(3.024e-06), .pd(2.54e-06), .nrs(0.135), .nrd(0.135), .m((1)*(10)), .par1((1)*(10)))
(* integer passed_mfactor = "m"; *)
 M39 (net017, net013, net018, net018);
pel #(.w(2e-06), .l(1e-05), .as(9.6e-13), .ad(9.6e-13), .ps(4.96e-06), .pd(4.96e-06), .nrs(0.135), .nrd(0.135), .m((1)*(1)), .par1((1)*(1)))
(* integer passed_mfactor = "m"; *)
 M38 (net013, net013, net08, net08);
pel #(.w(2e-06), .l(1e-05), .as(6.24e-13), .ad(5.4e-13), .ps(3.024e-06), .pd(2.54e-06), .nrs(0.135), .nrd(0.135), .m((1)*(10)), .par1((1)*(10)))
(* integer passed_mfactor = "m"; *)
 M34 (net018, net08, VDDA, VDDA);
pel #(.w(2e-06), .l(1e-05), .as(9.6e-13), .ad(9.6e-13), .ps(4.96e-06), .pd(4.96e-06), .nrs(0.135), .nrd(0.135), .m((1)*(1)), .par1((1)*(1)))
(* integer passed_mfactor = "m"; *)
 M33 (net08, net08, VDDA, VDDA);
pel #(.w(5e-07), .l(2e-06), .as(1.56e-13), .ad(1.56e-13), .ps(1.224e-06), .pd(1.224e-06), .nrs(0.54), .nrd(0.54), .m((1)*(5)), .par1((1)*(5)))
(* integer passed_mfactor = "m"; *)
 M4 (OUTP, OUTP, VDDA, VDDA);
pel #(.w(5e-07), .l(2e-06), .as(1.56e-13), .ad(1.56e-13), .ps(1.224e-06), .pd(1.224e-06), .nrs(0.54), .nrd(0.54), .m((1)*(5)), .par1((1)*(5)))
(* integer passed_mfactor = "m"; *)
 M3 (OUTN, OUTN, VDDA, VDDA);
pel #(.w(2e-05), .l(5e-07), .as(6.24e-12), .ad(5.4e-12), .ps(2.4624e-05), .pd(2.054e-05), .nrs(0.0135), .nrd(0.0135), .m((1)*(10)), .par1((1)*(10)))
(* integer passed_mfactor = "m"; *)
 M11 (net35, Vinn, VSn, VSn);
pel #(.w(5e-06), .l(3.5e-07), .as(1.56e-12), .ad(1.35e-12), .ps(6.624e-06), .pd(5.54e-06), .nrs(0.054), .nrd(0.054), .m((1)*(10)), .par1((1)*(10)))
(* integer passed_mfactor = "m"; *)
 M10 (cds_globals.\gnd! , net35, net015, net015);
pel #(.w(5e-06), .l(1e-05), .as(1.455e-12), .ad(1.35e-12), .ps(6.082e-06), .pd(5.54e-06), .nrs(0.054), .nrd(0.054), .m((1)*(20)), .par1((1)*(20)))
(* integer passed_mfactor = "m"; *)
 M31 (I_DSLn, net025, VDDA, VDDA);
pel #(.w(5e-07), .l(2e-06), .as(1.56e-13), .ad(1.35e-13), .ps(1.224e-06), .pd(1.04e-06), .nrs(0.54), .nrd(0.54), .m((1)*(10)), .par1((1)*(10)))
(* integer passed_mfactor = "m"; *)
 M0 (VSp, OUTP, VDDA, VDDA);
pel #(.w(5e-06), .l(3.5e-07), .as(1.56e-12), .ad(1.35e-12), .ps(6.624e-06), .pd(5.54e-06), .nrs(0.054), .nrd(0.054), .m((1)*(10)), .par1((1)*(10)))
(* integer passed_mfactor = "m"; *)
 M6 (cds_globals.\gnd! , net36, net8, net8);
pel #(.w(5e-06), .l(1e-05), .as(1.455e-12), .ad(1.35e-12), .ps(6.082e-06), .pd(5.54e-06), .nrs(0.054), .nrd(0.054), .m((1)*(20)), .par1((1)*(20)))
(* integer passed_mfactor = "m"; *)
 M30 (I_DSLp, net067, VDDA, VDDA);
pel #(.w(5e-07), .l(2e-06), .as(1.56e-13), .ad(1.35e-13), .ps(1.224e-06), .pd(1.04e-06), .nrs(0.54), .nrd(0.54), .m((1)*(10)), .par1((1)*(10)))
(* integer passed_mfactor = "m"; *)
 M5 (VSn, OUTN, VDDA, VDDA);
pel #(.w(1e-05), .l(5e-07), .as(4.8e-12), .ad(4.8e-12), .ps(2.096e-05), .pd(2.096e-05), .nrs(0.027), .nrd(0.027), .m((1)*(1)), .par1((1)*(1)))
(* integer passed_mfactor = "m"; *)
 M42 (net015, net015, net079, net079);
pel #(.w(2e-05), .l(5e-07), .as(6.24e-12), .ad(5.4e-12), .ps(2.4624e-05), .pd(2.054e-05), .nrs(0.0135), .nrd(0.0135), .m((1)*(10)), .par1((1)*(10)))
(* integer passed_mfactor = "m"; *)
 M1 (net36, Vinp, VSp, VSp);
iprobe IPRB0 (OUTN, net079);
iprobe IPRB1 (OUTP, net054);
nel #(.w(1e-06), .l(1.5e-05), .as(3.12e-13), .ad(3.12e-13), .ps(1.824e-06), .pd(1.824e-06), .nrs(0.27), .nrd(0.27), .m((1)*(5)), .par1((1)*(5)), .xf_subext(0))
(* integer passed_mfactor = "m"; *)
 M47 (net073, net04, cds_globals.\gnd! , cds_globals.\gnd! );
nel #(.w(1e-06), .l(1.5e-05), .as(3.12e-13), .ad(3.12e-13), .ps(1.824e-06), .pd(1.824e-06), .nrs(0.27), .nrd(0.27), .m((1)*(5)), .par1((1)*(5)), .xf_subext(0))
(* integer passed_mfactor = "m"; *)
 M48 (net062, net04, cds_globals.\gnd! , cds_globals.\gnd! );
nel #(.w(7.5e-07), .l(1.5e-05), .as(3.6e-13), .ad(2.025e-13), .ps(2.46e-06), .pd(1.29e-06), .nrs(0.36), .nrd(0.36), .m((1)*(2)), .par1((1)*(2)), .xf_subext(0))
(* integer passed_mfactor = "m"; *)
 M40 (net017, net017, net061, cds_globals.\gnd! );
nel #(.w(1e-06), .l(1.5e-05), .as(4.8e-13), .ad(4.8e-13), .ps(2.96e-06), .pd(2.96e-06), .nrs(0.27), .nrd(0.27), .m((1)*(1)), .par1((1)*(1)), .xf_subext(0))
(* integer passed_mfactor = "m"; *)
 M37 (net013, net06, net069, cds_globals.\gnd! );
nel #(.w(1e-06), .l(1.5e-05), .as(4.8e-13), .ad(4.8e-13), .ps(2.96e-06), .pd(2.96e-06), .nrs(0.27), .nrd(0.27), .m((1)*(1)), .par1((1)*(1)), .xf_subext(0))
(* integer passed_mfactor = "m"; *)
 M36 (net06, net06, net04, cds_globals.\gnd! );
nel #(.w(7.5e-07), .l(1.5e-05), .as(3.6e-13), .ad(2.025e-13), .ps(2.46e-06), .pd(1.29e-06), .nrs(0.36), .nrd(0.36), .m((1)*(2)), .par1((1)*(2)), .xf_subext(0))
(* integer passed_mfactor = "m"; *)
 M35 (net061, net061, cds_globals.\gnd! , cds_globals.\gnd! );
nel #(.w(1e-06), .l(1.5e-05), .as(4.8e-13), .ad(4.8e-13), .ps(2.96e-06), .pd(2.96e-06), .nrs(0.27), .nrd(0.27), .m((1)*(1)), .par1((1)*(1)), .xf_subext(0))
(* integer passed_mfactor = "m"; *)
 M29 (net04, net04, cds_globals.\gnd! , cds_globals.\gnd! );
nel #(.w(1e-06), .l(1.5e-05), .as(4.8e-13), .ad(4.8e-13), .ps(2.96e-06), .pd(2.96e-06), .nrs(0.27), .nrd(0.27), .m((1)*(1)), .par1((1)*(1)), .xf_subext(0))
(* integer passed_mfactor = "m"; *)
 M32 (net069, net04, cds_globals.\gnd! , cds_globals.\gnd! );
nel #(.w(1e-06), .l(1.5e-05), .as(4.8e-13), .ad(2.7e-13), .ps(2.96e-06), .pd(1.54e-06), .nrs(0.27), .nrd(0.27), .m((1)*(2)), .par1((1)*(2)), .xf_subext(0))
(* integer passed_mfactor = "m"; *)
 M43 (net036, net04, cds_globals.\gnd! , cds_globals.\gnd! );
nel #(.w(1e-06), .l(1.5e-05), .as(4.8e-13), .ad(2.7e-13), .ps(2.96e-06), .pd(1.54e-06), .nrs(0.27), .nrd(0.27), .m((1)*(2)), .par1((1)*(2)), .xf_subext(0))
(* integer passed_mfactor = "m"; *)
 M44 (net020, net04, cds_globals.\gnd! , cds_globals.\gnd! );
nel #(.w(7.5e-07), .l(1.5e-05), .as(2.15625e-13), .ad(2.025e-13), .ps(1.3875e-06), .pd(1.29e-06), .nrs(0.36), .nrd(0.36), .m((1)*(24)), .par1((1)*(24)), .xf_subext(0))
(* integer passed_mfactor = "m"; *)
 M15 (net35, net061, cds_globals.\gnd! , cds_globals.\gnd! );
nel #(.w(7.5e-07), .l(1.5e-05), .as(2.15625e-13), .ad(2.025e-13), .ps(1.3875e-06), .pd(1.29e-06), .nrs(0.36), .nrd(0.36), .m((1)*(24)), .par1((1)*(24)), .xf_subext(0))
(* integer passed_mfactor = "m"; *)
 M2 (net36, net061, cds_globals.\gnd! , cds_globals.\gnd! );
rpp1k1 #(.l(0.00100528), .w(2e-06), .m(1), .par1(1))
(* integer passed_mfactor = "m"; *)
 R1 (net062, net073);
rpp1k1 #(.l(5.056e-05), .w(2e-06), .m(1), .par1(1))
(* integer passed_mfactor = "m"; *)
 R0 (VSp, VSn);

endmodule
// Library - MultiChannel_EMG_IMP, Cell - Switch_NMOS, View - schematic
// LAST TIME SAVED: Oct  8 13:23:17 2021
// NETLIST TIME: Oct  8 15:51:09 2021

`worklib MultiChannel_EMG_IMP
`view schematic

`timescale 1ns / 1ps
(* cds_ams_schematic *)

module Switch_NMOS (A, B, VSSA, ctrl);
inout  A, B, VSSA, ctrl;
nel #(.w(1e-06), .l(1.8e-07), .as(3.12e-13), .ad(3.12e-13), .ps(1.824e-06), .pd(1.824e-06), .nrs(0.27), .nrd(0.27), .m((1)*(5)), .par1((1)*(5)), .xf_subext(0))
(* integer passed_mfactor = "m"; *)
 M0 (B, ctrl, A, VSSA);

endmodule
// Library - MultiChannel_EMG_IMP, Cell - Chopper, View - schematic
// LAST TIME SAVED: Oct  8 13:23:19 2021
// NETLIST TIME: Oct  8 15:51:09 2021

`worklib MultiChannel_EMG_IMP
`view schematic

`timescale 1ns / 1ps
(* cds_ams_schematic *)

module Chopper (INN, INP, OUTN, OUTP, VSSA, CLK, CLKB);
input  CLK, CLKB;
inout  INN, INP, OUTN, OUTP, VSSA;
Switch_NMOS I6 (.A( INN ), .VSSA( VSSA ), .ctrl( CLK ), .B( OUTN ));
Switch_NMOS I5 (.A( INN ), .VSSA( VSSA ), .ctrl( CLKB ), .B( OUTP ));
Switch_NMOS I4 (.A( INP ), .VSSA( VSSA ), .ctrl( CLKB ), .B( OUTN ));
Switch_NMOS I0 (.B( OUTP ), .A( INP ), .VSSA( VSSA ), .ctrl( CLK ));

endmodule
// Library - MultiChannel_EMG_IMP, Cell - PseudoResistor_45GOhm, View - schematic
// LAST TIME SAVED: Oct  7 14:34:26 2021
// NETLIST TIME: Oct  8 15:51:09 2021

`worklib MultiChannel_EMG_IMP
`view schematic

`timescale 1ns / 1ps
(* cds_ams_schematic *)

module PseudoResistor_45GOhm (A, B);
inout  A, B;
pel #(.w(3e-06), .l(2e-06), .as(1.02e-12), .ad(1.02e-12), .ps(4.68e-06), .pd(4.68e-06), .nrs(0.09), .nrd(0.09), .m((1)*(3)), .par1((1)*(3)))
(* integer passed_mfactor = "m"; *)
 M7 (net8, net8, B, net8);
pel #(.w(3e-06), .l(2e-06), .as(1.02e-12), .ad(1.02e-12), .ps(4.68e-06), .pd(4.68e-06), .nrs(0.09), .nrd(0.09), .m((1)*(3)), .par1((1)*(3)))
(* integer passed_mfactor = "m"; *)
 M6 (net9, net9, A, net9);
pel #(.w(3e-06), .l(2e-06), .as(1.44e-12), .ad(1.44e-12), .ps(6.96e-06), .pd(6.96e-06), .nrs(0.09), .nrd(0.09), .m((1)*(1)), .par1((1)*(1)))
(* integer passed_mfactor = "m"; *)
 M5 (net7, net7, net9, net9);
pel #(.w(3e-06), .l(2e-06), .as(1.44e-12), .ad(1.44e-12), .ps(6.96e-06), .pd(6.96e-06), .nrs(0.09), .nrd(0.09), .m((1)*(1)), .par1((1)*(1)))
(* integer passed_mfactor = "m"; *)
 M4 (net7, net7, net8, net8);

endmodule
`noworklib
`noview
