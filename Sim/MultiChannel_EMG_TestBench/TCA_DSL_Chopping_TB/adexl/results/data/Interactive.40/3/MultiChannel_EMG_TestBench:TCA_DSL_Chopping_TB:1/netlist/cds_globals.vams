// Verilog-AMS cds_globals module for top-level cell:
//    MultiChannel_EMG_TestBench/TCA_DSL_Chopping_TB.
// Generated by ADE.
// Cadence Design Systems, Inc.

// This is an autoGenerated file, any changes done to this file may get lost.

`include "disciplines.vams"
`include "userDisciplines.vams"

module cds_globals;

// Global Signals
   electrical \gnd! ;
   ground \gnd! ;

// Design Variables
   dynamicparam real Fchop = 36;
   dynamicparam real Amp_input = 1m;
   dynamicparam real CM_DC = 0.9;
   dynamicparam real Freq_input = 500;
   dynamicparam real Vos = 50m;

endmodule
