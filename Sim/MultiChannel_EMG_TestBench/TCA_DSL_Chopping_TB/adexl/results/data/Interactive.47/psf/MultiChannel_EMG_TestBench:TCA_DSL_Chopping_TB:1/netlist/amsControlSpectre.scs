// This is the Cadence AMS Designer(R) analog simulation control file.
// It specifies the options and analyses for the Spectre analog solver.

simulator lang=spectre

global 0

simulatorOptions options temp=27 tnom=27 scale=1.0 scalem=1.0 \
reltol=100e-6 vabstol=1e-6 iabstol=1e-12 homotopy=all limit=delta \
gmin=1e-12 rforce=1 maxnotes=5 maxwarns=5 digits=5 pivrel=1e-3 \
checklimitdest=psf

ac ac start=1 stop=1G dec=20 annotate=status

tran tran stop=10m errpreset=conservative write="spectre.ic" \
writefinal="spectre.fc" annotate=status maxiters=5

finalTimeOP info what=oppoint where=rawfile

modelParameter info what=models where=rawfile
element info what=inst where=rawfile
outputParameter info what=output where=rawfile

wave_out options rawfmt=sst2

save TCA_DSL_Chopping_TB.IPRB1:in TCA_DSL_Chopping_TB.IPRB0:in \
TCA_DSL_Chopping_TB.M30:1 TCA_DSL_Chopping_TB.M31:1 \
TCA_DSL_Chopping_TB.V0:p TCA_DSL_Chopping_TB.V1:p
