// Design: MultiChannel_EMG_TestBench/TCA_DSL_TB
simulator lang=spectre
global 0
parameters AMP_input=100u freq_input=500 VOS=0 Rint=16G
include "/pkg/xfab/XKIT/xh018/cadence/v8_0/spectre/v8_0_1/lpmos/config.scs" section=default
include "/pkg/xfab/XKIT/xh018/cadence/v8_0/spectre/v8_0_1/lpmos/param.scs" section=3s
include "/pkg/xfab/XKIT/xh018/cadence/v8_0/spectre/v8_0_1/lpmos/bip.scs" section=tm
include "/pkg/xfab/XKIT/xh018/cadence/v8_0/spectre/v8_0_1/lpmos/cap.scs" section=tm
include "/pkg/xfab/XKIT/xh018/cadence/v8_0/spectre/v8_0_1/lpmos/dio.scs" section=tm
include "/pkg/xfab/XKIT/xh018/cadence/v8_0/spectre/v8_0_1/lpmos/mos.scs" section=tm
include "/pkg/xfab/XKIT/xh018/cadence/v8_0/spectre/v8_0_1/lpmos/photo.scs" section=tm
include "/pkg/xfab/XKIT/xh018/cadence/v8_0/spectre/v8_0_1/lpmos/res.scs" section=tm

// MultiChannel_EMG_TestBench/TCA_DSL_TB/schematic
M8 (net63 net22 net24 0) ne w=2u l=500n m=(1)*(30)
M5 (net62 net31 net29 0) ne w=2u l=500n m=(1)*(30)
M31 (net31 net32 net28 0) ne w=10u l=20u m=(1)*(1)
M29 (net22 net20 net28 0) ne w=10u l=20u m=(1)*(1)
M20 (IBIAS2 IBIAS2 IBIAS 0) ne w=375.00n l=15.0u m=(1)*(20)
M21 (IBIAS IBIAS 0 0) ne w=375.00n l=15.0u m=(1)*(20)
M15 (net14 IBIAS 0 0) ne w=375.00n l=15.0u m=(1)*(20)
M2 (net10 IBIAS 0 0) ne w=375.00n l=15.0u m=(1)*(20)
V5 (net059 VCM) vsource dc=VOS type=dc
V2 (VCM 0) vsource dc=900m type=dc
V4 (VDDA 0) vsource dc=1.8 type=dc
M51 (net22 net27 VDDA VDDA) pe w=2u l=40u m=(1)*(1)
M53 (net27 net27 VDDA VDDA) pe w=2u l=40u m=(1)*(1)
M52 (net31 net27 VDDA VDDA) pe w=2u l=40u m=(1)*(1)
M9 (DSLoutn DSLoutn VDDA VDDA) pe w=4u l=10u m=(1)*(2)
M4 (DSLoutp DSLoutp VDDA VDDA) pe w=4u l=10u m=(1)*(2)
M54 (net13 DSLoutn VDDA VDDA) pe w=4u l=10u m=(3)*(2)
M55 (net12 DSLoutp VDDA VDDA) pe w=4u l=10u m=(3)*(2)
M0 (net12 outp VDDA VDDA) pe w=2u l=2u m=(1)*(20)
M7 (outp outp VDDA VDDA) pe w=2u l=2u m=(1)*(20)
M13 (net13 outn VDDA VDDA) pe w=2u l=2u m=(1)*(20)
M12 (outn outn VDDA VDDA) pe w=2u l=2u m=(1)*(20)
M1 (net10 Vinp net12 net12) pe w=10u l=500n m=(1)*(20)
M3 (net14 Vinn net13 net13) pe w=10u l=500n m=(1)*(20)
M6 (0 net10 net40 net40) pe w=8u l=180.0n m=(1)*(10)
M10 (0 net14 net17 net17) pe w=8u l=180.0n m=(1)*(10)
V1 (VCM Vinn) vsource mag=500.0m type=sine ampl=AMP_input freq=freq_input
V0 (Vinp net059) vsource mag=500.0m type=sine ampl=AMP_input freq=freq_input
I1 (VDDA IBIAS2) isource dc=2u type=dc
IPRB2 (DSLoutp net63) iprobe
IPRB3 (DSLoutn net62) iprobe
IPRB1 (outp net40) iprobe
IPRB0 (outn net17) iprobe
R1 (net12 net13) rpp1k1 l=20.09u w=2u m=1 par1=(1)
I36 (net27 0) isource dc=50n type=sine
I7 (net29 0) isource dc=500n type=sine
I2 (net24 0) isource dc=500n type=sine
I30 (net28 0) isource dc=100n type=sine
R3 (net20 net22) resistor r=Rint
R2 (net31 net32) resistor r=Rint
R6 (net64 net29) resistor r=25K
R5 (net24 net64) resistor r=25K
R0 (net32 outn) resistor r=Rint/20
R10 (outp net20) resistor r=Rint/20
C9 (net31 net32) capacitor c=5p
C8 (net22 net20) capacitor c=10p
simulatorOptions options reltol=100e-6 temp=27 homotopy=all limit=delta compatible=spice2
dcOp dc
ac ac start=1m stop=100M dec=20
save IPRB2:in IPRB1:in IPRB0:in M55:1
