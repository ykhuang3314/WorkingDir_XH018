// AMS netlist generated by the AMS Unified netlister
// IC subversion:  IC6.1.8-64b.500.7
// Xcelium version: 18.03-s018
// Copyright(C) 2005-2009, Cadence Design Systems, Inc
// User: ykhuang Pid: 7925
// Design library name: MultiChannel_EMG_TestBench
// Design cell name: MultiChannelAFE_TB_2
// Design view name: config
// Solver: Spectre

`include "disciplines.vams"
`include "userDisciplines.vams"
// HDL file - MultiChannel_EMG_Model, FrontEnd_Amplifier, verilogams.
// HDL file - MultiChannel_EMG_Model, LPF_Butter, verilogams.
// HDL file - MultiChannel_EMG_Model, ClockGen, functional.
// HDL file - MultiChannel_EMG_Model, ClockGenMultiFreq, functional.
// Library - MultiChannel_EMG_TestBench, Cell - MultiChannelAFE_TB_2, View - schematic
// LAST TIME SAVED: Oct 11 15:42:58 2021
// NETLIST TIME: Oct 11 15:43:11 2021

`worklib MultiChannel_EMG_TestBench
`view schematic

`timescale 1ns / 1ps
(* cds_ams_schematic *)

module MultiChannelAFE_TB_2 ( );
wire CLKB16;
wire CLKB15;
wire CLKB14;
wire CLKB13;
wire CLKB12;
wire CLKB11;
wire CLKB10;
wire CLKB9;
wire CLKB8;
wire CLKB7;
wire CLKB6;
wire CLKB5;
wire CLKB4;
wire CLKB3;
wire CLKB2;
wire CLKB1;
wire CLK16;
wire CLK15;
wire CLK14;
wire CLK13;
wire CLK12;
wire CLK11;
wire CLK10;
wire CLK9;
wire CLK8;
wire CLK7;
wire CLK6;
wire CLK5;
wire CLK4;
wire CLK3;
wire CLK2;
wire CLK1;
wire VOUTN_TIA;
wire VOUTP_TIA;
wire deModOUTN_CH1;
wire deModOUTP_CH1;
wire deModOUTN_CH2;
wire deModOUTP_CH2;
wire LPFOUTP_CH1;
wire LPFOUTN_CH1;
wire VDDA;
wire VCM;
wire LPFOUTP_CH2;
wire LPFOUTN_CH2;
wire INP_TIA;
wire INN_TIA;
wire VINP_CH2;
wire VINN_CH2;
wire net017;
wire net022;
wire net039;
wire VINP_CH1;
wire VINN_CH1;
wire net020;
wire net024;
wire net038;
ClockGenMultiFreq #(.fchop11(72), .fchop5(48), .fchop15(88), .fchop10(68), .fchop7(56), .fchop13(80), .fchop14(84), .fchop12(76), .fchop3(40), .fchop2(36), .fchop6(52), .fchop4(44), .fchop8(60), .fchop16(92), .fchop9(64)) I79 (.CLK1( CLK1 ), .CLK2( CLK2 ), .CLK3( CLK3 ), .CLK4( CLK4 ), .CLK5( CLK5 ), .CLK6( CLK6 ), .CLK7( CLK7 ), .CLK8( CLK8 ), .CLK9( CLK9 ), .CLK10( CLK10 ), .CLK11( CLK11 ), .CLK12( CLK12 ), .CLK13( CLK13 ), .CLK14( CLK14 ), .CLK15( CLK15 ), .CLK16( CLK16 ), .CLKB1( CLKB1 ), .CLKB2( CLKB2 ), .CLKB3( CLKB3 ), .CLKB4( CLKB4 ), .CLKB5( CLKB5 ), .CLKB6( CLKB6 ), .CLKB7( CLKB7 ), .CLKB8( CLKB8 ), .CLKB9( CLKB9 ), .CLKB10( CLKB10 ), .CLKB11( CLKB11 ), .CLKB12( CLKB12 ), .CLKB13( CLKB13 ), .CLKB14( CLKB14 ), .CLKB15( CLKB15 ), .CLKB16( CLKB16 ));
Chopper I77 (.VSSA(cds_globals.\gnd! ), .CLKB( CLKB1 ), .CLK( CLK1 ), .OUTP( deModOUTP_CH1 ), .OUTN( deModOUTN_CH1 ), .INP( VOUTP_TIA ), .INN( VOUTN_TIA ));
Chopper I76 (.VSSA(cds_globals.\gnd! ), .CLKB( CLKB2 ), .CLK( CLK2 ), .OUTP( deModOUTP_CH2 ), .OUTN( deModOUTN_CH2 ), .INP( VOUTP_TIA ), .INN( VOUTN_TIA ));
LPF_Butter I34 (.VCM( VCM ), .VDDA( VDDA ), .VSSA(cds_globals.\gnd! ), .Voutn( LPFOUTN_CH1 ), .Voutp( LPFOUTP_CH1 ), .Vinn( deModOUTN_CH1 ), .Vinp( deModOUTP_CH1 ));
LPF_Butter I35 (.VCM( VCM ), .VDDA( VDDA ), .VSSA(cds_globals.\gnd! ), .Voutn( LPFOUTN_CH2 ), .Voutp( LPFOUTP_CH2 ), .Vinn( deModOUTN_CH2 ), .Vinp( deModOUTP_CH2 ));
FrontEnd_Amplifier #(.fp1(100000), .gain(1000)) I3 (.VDDA( VDDA ), .VSSA(cds_globals.\gnd! ), .Vcm( VCM ), .Vsub(cds_globals.\gnd! ), .Voutn( VOUTN_TIA ), .Voutp( VOUTP_TIA ), .Vinn( INN_TIA ), .Vinp( INP_TIA ));
ChoppingTCA_DSL_imp I74 (.IBIAS( net039 ), .VDDA( VDDA ), .VSSA(cds_globals.\gnd! ), .OUTN( net022 ), .OUTP( net017 ), .CLK( CLK2 ), .CLKB( CLKB2 ), .VINN( VINN_CH2 ), .VINP( VINP_CH2 ));
ChoppingTCA_DSL_imp I73 (.IBIAS( net038 ), .VDDA( VDDA ), .VSSA(cds_globals.\gnd! ), .OUTN( net024 ), .OUTP( net020 ), .CLK( CLK1 ), .CLKB( CLKB1 ), .VINN( VINN_CH1 ), .VINP( VINP_CH1 ));
pel #(.w(5e-07), .l(2e-06), .as(1.56e-13), .ad(1.56e-13), .ps(1.224e-06), .pd(1.224e-06), .nrs(0.54), .nrd(0.54), .m((1)*(5)), .par1((1)*(5)))
(* integer passed_mfactor = "m"; *)
 M2 (net4, net024, VDDA, VDDA);
pel #(.w(5e-07), .l(2e-06), .as(1.56e-13), .ad(1.56e-13), .ps(1.224e-06), .pd(1.224e-06), .nrs(0.54), .nrd(0.54), .m((1)*(5)), .par1((1)*(5)))
(* integer passed_mfactor = "m"; *)
 M1 (net3, net020, VDDA, VDDA);
pel #(.w(5e-07), .l(2e-06), .as(1.56e-13), .ad(1.56e-13), .ps(1.224e-06), .pd(1.224e-06), .nrs(0.54), .nrd(0.54), .m((1)*(5)), .par1((1)*(5)))
(* integer passed_mfactor = "m"; *)
 M4 (net3, net017, VDDA, VDDA);
pel #(.w(5e-07), .l(2e-06), .as(1.56e-13), .ad(1.56e-13), .ps(1.224e-06), .pd(1.224e-06), .nrs(0.54), .nrd(0.54), .m((1)*(5)), .par1((1)*(5)))
(* integer passed_mfactor = "m"; *)
 M0 (net4, net022, VDDA, VDDA);
vsource #(.dc(cds_globals.VOS), .type("dc")) V8 (net26, VIN_CM_CH2);
vsource #(.dc(0.9), .type("dc")) V7 (VCM, cds_globals.\gnd! );
vsource #(.dc(1.8), .type("dc")) V4 (VDDA, cds_globals.\gnd! );
vsource #(.dc(cds_globals.VOS), .type("dc")) V3 (net30, VIN_CM_CH1);
vsource #(.mag(cds_globals.VIN_AC/2), .type("sine"), .delay(1/(cds_globals.fsig*16*1)), .ampl(cds_globals.AMP/2), .freq(cds_globals.fsig)) V11 (VIN_CM_CH2, VINN_CH2);
vsource #(.mag(cds_globals.VIN_AC/2), .type("sine"), .delay(1/(cds_globals.fsig*16*1)), .ampl(cds_globals.AMP/2), .freq(cds_globals.fsig)) V10 (VINP_CH2, net26);
vsource #(.dc(cds_globals.VCM), .mag(cds_globals.VCM_AC), .type("sine")) V9 (VIN_CM_CH2, cds_globals.\gnd! );
vsource #(.mag(cds_globals.VIN_AC/2), .type("sine"), .ampl(-cds_globals.AMP/2), .freq(cds_globals.fsig)) V1 (VIN_CM_CH1, VINN_CH1);
vsource #(.mag(cds_globals.VIN_AC/2), .type("sine"), .ampl(-cds_globals.AMP/2), .freq(cds_globals.fsig)) V0 (VINP_CH1, net30);
vsource #(.dc(cds_globals.VCM), .mag(cds_globals.VCM_AC), .type("sine")) V2 (VIN_CM_CH1, cds_globals.\gnd! );
iprobe IPRB5 (net4, INN_TIA);
iprobe IPRB4 (net3, INP_TIA);
isource #(.dc(5e-08), .type("dc")) I38 (VDDA, net038);
isource #(.dc(5e-08), .type("dc")) I1 (VDDA, net039);
resistor #(.r(500000)) R3 (INN_TIA, VOUTP_TIA);
resistor #(.r(500000)) R2 (INP_TIA, VOUTN_TIA);
capacitor #(.c(3e-12)) C1 (INN_TIA, VOUTP_TIA);
capacitor #(.c(3e-12)) C0 (INP_TIA, VOUTN_TIA);
vcvs #(.gain(1)) E0 (VOUT_CH1, cds_globals.\gnd! , LPFOUTP_CH1, LPFOUTN_CH1);
vcvs #(.gain(1)) E1 (VOUT_CH2, cds_globals.\gnd! , LPFOUTP_CH2, LPFOUTN_CH2);

endmodule
// Library - MultiChannel_EMG_IMP, Cell - Switch_NMOS, View - schematic
// LAST TIME SAVED: Oct  8 13:23:17 2021
// NETLIST TIME: Oct 11 15:43:11 2021

`worklib MultiChannel_EMG_IMP
`view schematic

`timescale 1ns / 1ps
(* cds_ams_schematic *)

module Switch_NMOS (A, B, VSSA, ctrl);
inout  A, B, VSSA, ctrl;
nel #(.w(1e-06), .l(1.8e-07), .as(3.12e-13), .ad(3.12e-13), .ps(1.824e-06), .pd(1.824e-06), .nrs(0.27), .nrd(0.27), .m((1)*(5)), .par1((1)*(5)), .xf_subext(0))
(* integer passed_mfactor = "m"; *)
 M0 (B, ctrl, A, VSSA);

endmodule
// Library - MultiChannel_EMG_IMP, Cell - Chopper, View - schematic
// LAST TIME SAVED: Oct  8 13:23:19 2021
// NETLIST TIME: Oct 11 15:43:11 2021

`worklib MultiChannel_EMG_IMP
`view schematic

`timescale 1ns / 1ps
(* cds_ams_schematic *)

module Chopper (INN, INP, OUTN, OUTP, VSSA, CLK, CLKB);
input  CLK, CLKB;
inout  INN, INP, OUTN, OUTP, VSSA;
Switch_NMOS I6 (.A( INN ), .VSSA( VSSA ), .ctrl( CLK ), .B( OUTN ));
Switch_NMOS I5 (.A( INN ), .VSSA( VSSA ), .ctrl( CLKB ), .B( OUTP ));
Switch_NMOS I4 (.A( INP ), .VSSA( VSSA ), .ctrl( CLKB ), .B( OUTN ));
Switch_NMOS I0 (.B( OUTP ), .A( INP ), .VSSA( VSSA ), .ctrl( CLK ));

endmodule
// Library - MultiChannel_EMG_IMP, Cell - PseudoResistor_45GOhm, View - schematic
// LAST TIME SAVED: Oct  7 14:34:26 2021
// NETLIST TIME: Oct 11 15:43:11 2021

`worklib MultiChannel_EMG_IMP
`view schematic

`timescale 1ns / 1ps
(* cds_ams_schematic *)

module PseudoResistor_45GOhm (A, B);
inout  A, B;
pel #(.w(3e-06), .l(2e-06), .as(1.02e-12), .ad(1.02e-12), .ps(4.68e-06), .pd(4.68e-06), .nrs(0.09), .nrd(0.09), .m((1)*(3)), .par1((1)*(3)))
(* integer passed_mfactor = "m"; *)
 M7 (net8, net8, B, net8);
pel #(.w(3e-06), .l(2e-06), .as(1.02e-12), .ad(1.02e-12), .ps(4.68e-06), .pd(4.68e-06), .nrs(0.09), .nrd(0.09), .m((1)*(3)), .par1((1)*(3)))
(* integer passed_mfactor = "m"; *)
 M6 (net9, net9, A, net9);
pel #(.w(3e-06), .l(2e-06), .as(1.44e-12), .ad(1.44e-12), .ps(6.96e-06), .pd(6.96e-06), .nrs(0.09), .nrd(0.09), .m((1)*(1)), .par1((1)*(1)))
(* integer passed_mfactor = "m"; *)
 M5 (net7, net7, net9, net9);
pel #(.w(3e-06), .l(2e-06), .as(1.44e-12), .ad(1.44e-12), .ps(6.96e-06), .pd(6.96e-06), .nrs(0.09), .nrd(0.09), .m((1)*(1)), .par1((1)*(1)))
(* integer passed_mfactor = "m"; *)
 M4 (net7, net7, net8, net8);

endmodule
// Library - MultiChannel_EMG_IMP, Cell - ChoppingTCA_DSL_imp, View - schematic
// LAST TIME SAVED: Oct  8 16:21:00 2021
// NETLIST TIME: Oct 11 15:43:11 2021

`worklib MultiChannel_EMG_IMP
`view schematic

`timescale 1ns / 1ps
(* cds_ams_schematic *)

module ChoppingTCA_DSL_imp (OUTN, OUTP, IBIAS, VDDA, VSSA, CLK, CLKB, VINN, VINP);
output  OUTN, OUTP;
input  CLK, CLKB, VINN, VINP;
inout  IBIAS, VDDA, VSSA;
wire VSn;
wire VSp;
wire net85;
wire net81;
wire inn_chop;
wire inp_chop;
wire I_DSLp;
wire I_DSLn;
wire net43;
wire LPFoutp;
wire LPFoutn;
wire net84;
Chopper I37 (.VSSA( VSSA ), .CLKB( CLKB ), .CLK( CLK ), .OUTP( net81 ), .OUTN( net85 ), .INP( VSp ), .INN( VSn ));
Chopper I36 (.VSSA( VSSA ), .CLKB( CLKB ), .CLK( CLK ), .OUTP( inp_chop ), .OUTN( inn_chop ), .INP( VINP ), .INN( VINN ));
Chopper I40 (.VSSA( VSSA ), .CLKB( CLKB ), .CLK( CLK ), .OUTP( VSp ), .OUTN( VSn ), .INP( I_DSLn ), .INN( I_DSLp ));
PseudoResistor_45GOhm I34 (.B( LPFoutp ), .A( net43 ));
PseudoResistor_45GOhm I35 (.B( net84 ), .A( LPFoutn ));
pel #(.w(2e-06), .l(1e-05), .as(6.24e-13), .ad(5.4e-13), .ps(3.024e-06), .pd(2.54e-06), .nrs(0.135), .nrd(0.135), .m((1)*(10)), .par1((1)*(10)))
(* integer passed_mfactor = "m"; *)
 M34 (net29, net23, VDDA, VDDA);
pel #(.w(2e-06), .l(1e-05), .as(9.6e-13), .ad(9.6e-13), .ps(4.96e-06), .pd(4.96e-06), .nrs(0.135), .nrd(0.135), .m((1)*(1)), .par1((1)*(1)))
(* integer passed_mfactor = "m"; *)
 M33 (net23, net23, VDDA, VDDA);
pel #(.w(5e-07), .l(2e-06), .as(1.56e-13), .ad(1.56e-13), .ps(1.224e-06), .pd(1.224e-06), .nrs(0.54), .nrd(0.54), .m((1)*(5)), .par1((1)*(5)))
(* integer passed_mfactor = "m"; *)
 M4 (OUTP, OUTP, VDDA, VDDA);
pel #(.w(5e-07), .l(2e-06), .as(1.56e-13), .ad(1.56e-13), .ps(1.224e-06), .pd(1.224e-06), .nrs(0.54), .nrd(0.54), .m((1)*(5)), .par1((1)*(5)))
(* integer passed_mfactor = "m"; *)
 M3 (OUTN, OUTN, VDDA, VDDA);
pel #(.w(5e-07), .l(2e-06), .as(1.56e-13), .ad(1.35e-13), .ps(1.224e-06), .pd(1.04e-06), .nrs(0.54), .nrd(0.54), .m((1)*(10)), .par1((1)*(10)))
(* integer passed_mfactor = "m"; *)
 M0 (VSp, OUTP, VDDA, VDDA);
pel #(.w(5e-07), .l(2e-06), .as(1.56e-13), .ad(1.35e-13), .ps(1.224e-06), .pd(1.04e-06), .nrs(0.54), .nrd(0.54), .m((1)*(10)), .par1((1)*(10)))
(* integer passed_mfactor = "m"; *)
 M5 (VSn, OUTN, VDDA, VDDA);
pel #(.w(5e-06), .l(1e-05), .as(1.455e-12), .ad(1.35e-12), .ps(6.082e-06), .pd(5.54e-06), .nrs(0.054), .nrd(0.054), .m((1)*(20)), .par1((1)*(20)))
(* integer passed_mfactor = "m"; *)
 M30 (I_DSLp, net59, VDDA, VDDA);
pel #(.w(5e-06), .l(1e-05), .as(2.4e-12), .ad(2.4e-12), .ps(1.096e-05), .pd(1.096e-05), .nrs(0.054), .nrd(0.054), .m((1)*(1)), .par1((1)*(1)))
(* integer passed_mfactor = "m"; *)
 M27 (net50, net52, VDDA, VDDA);
pel #(.w(2e-06), .l(1e-05), .as(9.6e-13), .ad(9.6e-13), .ps(4.96e-06), .pd(4.96e-06), .nrs(0.135), .nrd(0.135), .m((1)*(1)), .par1((1)*(1)))
(* integer passed_mfactor = "m"; *)
 M46 (net59, net23, VDDA, VDDA);
pel #(.w(2e-06), .l(1e-05), .as(9.6e-13), .ad(9.6e-13), .ps(4.96e-06), .pd(4.96e-06), .nrs(0.135), .nrd(0.135), .m((1)*(1)), .par1((1)*(1)))
(* integer passed_mfactor = "m"; *)
 M45 (net52, net23, VDDA, VDDA);
pel #(.w(2e-06), .l(1e-05), .as(6.24e-13), .ad(5.4e-13), .ps(3.024e-06), .pd(2.54e-06), .nrs(0.135), .nrd(0.135), .m((1)*(10)), .par1((1)*(10)))
(* integer passed_mfactor = "m"; *)
 M39 (net28, net22, net29, net29);
pel #(.w(2e-06), .l(1e-05), .as(9.6e-13), .ad(9.6e-13), .ps(4.96e-06), .pd(4.96e-06), .nrs(0.135), .nrd(0.135), .m((1)*(1)), .par1((1)*(1)))
(* integer passed_mfactor = "m"; *)
 M38 (net22, net22, net23, net23);
pel #(.w(1e-05), .l(5e-07), .as(4.8e-12), .ad(4.8e-12), .ps(2.096e-05), .pd(2.096e-05), .nrs(0.027), .nrd(0.027), .m((1)*(1)), .par1((1)*(1)))
(* integer passed_mfactor = "m"; *)
 M41 (net66, net66, OUTP, OUTP);
pel #(.w(1e-05), .l(5e-07), .as(4.8e-12), .ad(4.8e-12), .ps(2.096e-05), .pd(2.096e-05), .nrs(0.027), .nrd(0.027), .m((1)*(1)), .par1((1)*(1)))
(* integer passed_mfactor = "m"; *)
 M42 (net74, net74, OUTN, OUTN);
pel #(.w(2e-05), .l(5e-07), .as(6.24e-12), .ad(5.4e-12), .ps(2.4624e-05), .pd(2.054e-05), .nrs(0.0135), .nrd(0.0135), .m((1)*(10)), .par1((1)*(10)))
(* integer passed_mfactor = "m"; *)
 M11 (net37, inn_chop, VSn, VSn);
pel #(.w(2e-05), .l(5e-07), .as(6.24e-12), .ad(5.4e-12), .ps(2.4624e-05), .pd(2.054e-05), .nrs(0.0135), .nrd(0.0135), .m((1)*(10)), .par1((1)*(10)))
(* integer passed_mfactor = "m"; *)
 M1 (net34, inp_chop, VSp, VSp);
pel #(.w(5e-06), .l(3.5e-07), .as(1.56e-12), .ad(1.35e-12), .ps(6.624e-06), .pd(5.54e-06), .nrs(0.054), .nrd(0.054), .m((1)*(10)), .par1((1)*(10)))
(* integer passed_mfactor = "m"; *)
 M10 (VSSA, net37, net74, net74);
pel #(.w(5e-06), .l(3.5e-07), .as(1.56e-12), .ad(1.35e-12), .ps(6.624e-06), .pd(5.54e-06), .nrs(0.054), .nrd(0.054), .m((1)*(10)), .par1((1)*(10)))
(* integer passed_mfactor = "m"; *)
 M6 (VSSA, net34, net66, net66);
pel #(.w(5e-06), .l(1e-05), .as(2.4e-12), .ad(2.4e-12), .ps(1.096e-05), .pd(1.096e-05), .nrs(0.054), .nrd(0.054), .m((1)*(1)), .par1((1)*(1)))
(* integer passed_mfactor = "m"; *)
 M28 (net88, net59, VDDA, VDDA);
pel #(.w(5e-06), .l(1e-05), .as(1.455e-12), .ad(1.35e-12), .ps(6.082e-06), .pd(5.54e-06), .nrs(0.054), .nrd(0.054), .m((1)*(20)), .par1((1)*(20)))
(* integer passed_mfactor = "m"; *)
 M31 (I_DSLn, net52, VDDA, VDDA);
neli #(.w(4e-06), .l(1e-06), .as(1.248e-12), .ad(1.08e-12), .ps(5.424e-06), .pd(4.54e-06), .nrs(0.0675), .nrd(0.0675), .m((1)*(10)), .par1((1)*(10)))
(* integer passed_mfactor = "m"; *)
 M9 (VDDA, net85, net84, net84);
neli #(.w(4e-06), .l(1e-06), .as(1.248e-12), .ad(1.08e-12), .ps(5.424e-06), .pd(4.54e-06), .nrs(0.0675), .nrd(0.0675), .m((1)*(10)), .par1((1)*(10)))
(* integer passed_mfactor = "m"; *)
 M8 (VDDA, net81, net43, net43);
neli #(.w(2e-05), .l(5e-07), .as(9.6e-12), .ad(5.4e-12), .ps(4.096e-05), .pd(2.054e-05), .nrs(0.0135), .nrd(0.0135), .m((1)*(2)), .par1((1)*(2)))
(* integer passed_mfactor = "m"; *)
 M23 (net52, LPFoutp, net50, net50);
neli #(.w(2e-05), .l(5e-07), .as(9.6e-12), .ad(5.4e-12), .ps(4.096e-05), .pd(2.054e-05), .nrs(0.0135), .nrd(0.0135), .m((1)*(2)), .par1((1)*(2)))
(* integer passed_mfactor = "m"; *)
 M24 (net59, LPFoutn, net88, net88);
nel #(.w(7.5e-07), .l(1.5e-05), .as(3.6e-13), .ad(2.025e-13), .ps(2.46e-06), .pd(1.29e-06), .nrs(0.36), .nrd(0.36), .m((1)*(2)), .par1((1)*(2)), .xf_subext(0))
(* integer passed_mfactor = "m"; *)
 M40 (net28, net28, net36, VSSA);
nel #(.w(1e-06), .l(1.5e-05), .as(4.8e-13), .ad(4.8e-13), .ps(2.96e-06), .pd(2.96e-06), .nrs(0.27), .nrd(0.27), .m((1)*(1)), .par1((1)*(1)), .xf_subext(0))
(* integer passed_mfactor = "m"; *)
 M37 (net22, IBIAS, net95, VSSA);
nel #(.w(1e-06), .l(1.5e-05), .as(4.8e-13), .ad(4.8e-13), .ps(2.96e-06), .pd(2.96e-06), .nrs(0.27), .nrd(0.27), .m((1)*(1)), .par1((1)*(1)), .xf_subext(0))
(* integer passed_mfactor = "m"; *)
 M36 (IBIAS, IBIAS, net55, VSSA);
nel #(.w(1e-06), .l(1.5e-05), .as(3.12e-13), .ad(3.12e-13), .ps(1.824e-06), .pd(1.824e-06), .nrs(0.27), .nrd(0.27), .m((1)*(5)), .par1((1)*(5)), .xf_subext(0))
(* integer passed_mfactor = "m"; *)
 M48 (net50, net55, VSSA, VSSA);
nel #(.w(1e-06), .l(1.5e-05), .as(4.8e-13), .ad(2.7e-13), .ps(2.96e-06), .pd(1.54e-06), .nrs(0.27), .nrd(0.27), .m((1)*(2)), .par1((1)*(2)), .xf_subext(0))
(* integer passed_mfactor = "m"; *)
 M43 (net84, net55, VSSA, VSSA);
nel #(.w(1e-06), .l(1.5e-05), .as(4.8e-13), .ad(2.7e-13), .ps(2.96e-06), .pd(1.54e-06), .nrs(0.27), .nrd(0.27), .m((1)*(2)), .par1((1)*(2)), .xf_subext(0))
(* integer passed_mfactor = "m"; *)
 M44 (net43, net55, VSSA, VSSA);
nel #(.w(1e-06), .l(1.5e-05), .as(4.8e-13), .ad(4.8e-13), .ps(2.96e-06), .pd(2.96e-06), .nrs(0.27), .nrd(0.27), .m((1)*(1)), .par1((1)*(1)), .xf_subext(0))
(* integer passed_mfactor = "m"; *)
 M29 (net55, net55, VSSA, VSSA);
nel #(.w(1e-06), .l(1.5e-05), .as(4.8e-13), .ad(4.8e-13), .ps(2.96e-06), .pd(2.96e-06), .nrs(0.27), .nrd(0.27), .m((1)*(1)), .par1((1)*(1)), .xf_subext(0))
(* integer passed_mfactor = "m"; *)
 M32 (net95, net55, VSSA, VSSA);
nel #(.w(7.5e-07), .l(1.5e-05), .as(2.15625e-13), .ad(2.025e-13), .ps(1.3875e-06), .pd(1.29e-06), .nrs(0.36), .nrd(0.36), .m((1)*(24)), .par1((1)*(24)), .xf_subext(0))
(* integer passed_mfactor = "m"; *)
 M15 (net37, net36, VSSA, VSSA);
nel #(.w(7.5e-07), .l(1.5e-05), .as(2.15625e-13), .ad(2.025e-13), .ps(1.3875e-06), .pd(1.29e-06), .nrs(0.36), .nrd(0.36), .m((1)*(24)), .par1((1)*(24)), .xf_subext(0))
(* integer passed_mfactor = "m"; *)
 M2 (net34, net36, VSSA, VSSA);
nel #(.w(7.5e-07), .l(1.5e-05), .as(3.6e-13), .ad(2.025e-13), .ps(2.46e-06), .pd(1.29e-06), .nrs(0.36), .nrd(0.36), .m((1)*(2)), .par1((1)*(2)), .xf_subext(0))
(* integer passed_mfactor = "m"; *)
 M35 (net36, net36, VSSA, VSSA);
nel #(.w(1e-06), .l(1.5e-05), .as(3.12e-13), .ad(3.12e-13), .ps(1.824e-06), .pd(1.824e-06), .nrs(0.27), .nrd(0.27), .m((1)*(5)), .par1((1)*(5)), .xf_subext(0))
(* integer passed_mfactor = "m"; *)
 M47 (net88, net55, VSSA, VSSA);
capacitor #(.c(5e-12)) C6 (net23, VSSA);
capacitor #(.c(5e-12)) C1 (net55, VSSA);
capacitor #(.c(5e-12)) C0 (LPFoutp, LPFoutn);
capacitor #(.c(5e-12)) C2 (net36, VSSA);
rpp1k1 #(.l(5.056e-05), .w(2e-06), .m(1), .par1(1))
(* integer passed_mfactor = "m"; *)
 R0 (VSp, VSn);
rpp1k1 #(.l(0.00100528), .w(2e-06), .m(1), .par1(1))
(* integer passed_mfactor = "m"; *)
 R1 (net50, net88);

endmodule
`noworklib
`noview
