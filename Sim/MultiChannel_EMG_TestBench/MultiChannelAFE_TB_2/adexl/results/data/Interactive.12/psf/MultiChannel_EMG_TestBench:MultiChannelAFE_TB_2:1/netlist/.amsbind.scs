// -----------------------------------------------------------------------------
// (c) Copyright 2010 Cadence Design Systems, Inc. All rights reserved worldwide.
// -----------------------------------------------------------------------------

// Binding AMSD Control Block for config MultiChannel_EMG_TestBench.MultiChannelAFE_TB_2:config
// Created On: Oct 11 15:35:16 2021
// NOTE      : DO NOT change this system generated file.

amsd {
	config designtop="MultiChannel_EMG_TestBench.MultiChannelAFE_TB_2:schematic"

	config cell="FrontEnd_Amplifier" lib="MultiChannel_EMG_Model" view="verilogams"
	config cell="vcvs" view="analogtext"
	config cell="nel" view="analogtext"
	config cell="neli" view="analogtext"
	config cell="capacitor" view="analogtext"
	config cell="ClockGen" lib="MultiChannel_EMG_Model" view="functional"
	config cell="isource" view="analogtext"
	config cell="resistor" view="analogtext"
	config cell="ChoppingTCA_DSL_imp" lib="MultiChannel_EMG_IMP" view="schematic"
	config cell="vsource" view="analogtext"
	config cell="PseudoResistor_45GOhm" lib="MultiChannel_EMG_IMP" view="schematic"
	config cell="LPF_Butter" lib="MultiChannel_EMG_Model" view="verilogams"
	config cell="ClockGenMultiFreq" lib="MultiChannel_EMG_Model" view="functional"
	config cell="Switch_NMOS" lib="MultiChannel_EMG_IMP" view="schematic"
	config cell="pel" view="analogtext"
	config cell="iprobe" view="analogtext"
	config cell="rpp1k1" view="analogtext"
	config cell="Chopper" lib="MultiChannel_EMG_IMP" view="schematic"

 }
