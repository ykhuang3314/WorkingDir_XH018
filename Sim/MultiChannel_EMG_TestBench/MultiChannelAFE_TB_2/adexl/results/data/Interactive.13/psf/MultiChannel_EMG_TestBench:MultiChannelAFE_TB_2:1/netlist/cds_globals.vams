// Verilog-AMS cds_globals module for top-level cell:
//    MultiChannel_EMG_TestBench/MultiChannelAFE_TB_2.
// Generated by ADE.
// Cadence Design Systems, Inc.

// This is an autoGenerated file, any changes done to this file may get lost.

`include "disciplines.vams"
`include "userDisciplines.vams"

module cds_globals;

// Global Signals
   electrical \gnd! ;
   ground \gnd! ;

// Design Variables
   dynamicparam real AMP = 100u;
   dynamicparam real fsig = 500;
   dynamicparam real VCM = 900m;
   dynamicparam real VCM_AC = 0;
   dynamicparam real VIN_AC = 0;
   dynamicparam real VOS = 10m;

endmodule
