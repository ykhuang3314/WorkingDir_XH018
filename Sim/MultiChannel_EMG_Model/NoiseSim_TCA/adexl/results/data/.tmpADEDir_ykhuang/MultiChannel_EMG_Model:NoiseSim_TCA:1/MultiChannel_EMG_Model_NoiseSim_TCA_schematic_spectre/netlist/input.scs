// Design: MultiChannel_EMG_Model/NoiseSim_TCA
simulator lang=spectre
global 0
parameters IDS_PMOS=2.5u L_P=500n NF_P=10 VDS_PMOS=0.5 VGS_PMOS=0.59 WF_P=15u IDS=10u L=500n NF=25 VDS=0.5 VGS=0.503 WF=10u
include "/pkg/xfab/XKIT/xh018/cadence/v8_0/spectre/v8_0_1/lpmos/config.scs" section=default
include "/pkg/xfab/XKIT/xh018/cadence/v8_0/spectre/v8_0_1/lpmos/param.scs" section=3s
include "/pkg/xfab/XKIT/xh018/cadence/v8_0/spectre/v8_0_1/lpmos/bip.scs" section=tm
include "/pkg/xfab/XKIT/xh018/cadence/v8_0/spectre/v8_0_1/lpmos/cap.scs" section=tm
include "/pkg/xfab/XKIT/xh018/cadence/v8_0/spectre/v8_0_1/lpmos/dio.scs" section=tm
include "/pkg/xfab/XKIT/xh018/cadence/v8_0/spectre/v8_0_1/lpmos/mos.scs" section=tm
include "/pkg/xfab/XKIT/xh018/cadence/v8_0/spectre/v8_0_1/lpmos/photo.scs" section=tm
include "/pkg/xfab/XKIT/xh018/cadence/v8_0/spectre/v8_0_1/lpmos/res.scs" section=tm

// MultiChannel_EMG_Model/NoiseSim_TCA/schematic
M0 (net2 net7 net1 net1) ne w=WF l=L m=(1)*(NF)
I7 (net021 net03) isource dc=IDS_PMOS type=dc
I0 (net1 net2) isource dc=IDS type=dc
V7 (net023 net021) vsource dc=VDS_PMOS type=dc
V10 (net015 0) vsource dc=1.8 type=dc
V11 (net022 0) vsource dc=1.8 type=dc
V6 (net022 net07) vsource dc=VGS_PMOS type=dc
V1 (net3 0) vsource dc=VGS type=dc
V0 (net2 net9) vsource dc=VDS type=dc
E3 (net014 net03 net023 net03) vcvs gain=1000
E0 (net8 net1 net9 net1) vcvs gain=1000
IPRB2 (net014 0) iprobe
IPRB0 (0 net8) iprobe
V5 (net010 net07) vsource mag=1 type=sine
V2 (net7 net3) vsource mag=1 type=sine
R3 (net03 net015) resistor r=20K
R0 (net1 0) resistor r=10K
M1 (net021 net010 net03 net03) pe w=WF_P l=L_P m=(1)*(NF_P)
simulatorOptions options reltol=100e-6 temp=27 homotopy=all limit=delta compatible=spice2
noise noise start=10 stop=100M oprobe=IPRB2 iprobe=V5
dcOp dc
save IPRB2:in
