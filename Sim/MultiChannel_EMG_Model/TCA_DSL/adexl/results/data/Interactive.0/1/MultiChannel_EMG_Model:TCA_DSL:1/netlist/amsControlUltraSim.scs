// This is the Cadence AMS Designer(R) analog simulation control file.
// It specifies the options and analyses for the UltraSim analog solver.

simulator lang=spectre

global 0

simulatorOptions options temp=27 tnom=27 scale=1.0 scalem=1.0

// UltraSim Solver Options
usim_opt output_upper=0 ade=1 wf_spectre_syntax=1

dcOpInfo info what=oppoint where=rawfile writedc="dcOp"

modelParameter info what=models where=rawfile
element info what=inst where=rawfile
outputParameter info what=output where=rawfile

save TCA_DSL.IPRB1:in TCA_DSL.IPRB2:in
