// Design: MultiChannel_EMG_IMP/TCA_DSL_v2
simulator lang=spectre
global 0
parameters AMP_input=100u freq_input=500 VOS=50m
include "/pkg/xfab/XKIT/xh018/cadence/v8_0/spectre/v8_0_1/lpmos/config.scs" section=default
include "/pkg/xfab/XKIT/xh018/cadence/v8_0/spectre/v8_0_1/lpmos/param.scs" section=3s
include "/pkg/xfab/XKIT/xh018/cadence/v8_0/spectre/v8_0_1/lpmos/bip.scs" section=tm
include "/pkg/xfab/XKIT/xh018/cadence/v8_0/spectre/v8_0_1/lpmos/cap.scs" section=tm
include "/pkg/xfab/XKIT/xh018/cadence/v8_0/spectre/v8_0_1/lpmos/dio.scs" section=tm
include "/pkg/xfab/XKIT/xh018/cadence/v8_0/spectre/v8_0_1/lpmos/mos.scs" section=tm
include "/pkg/xfab/XKIT/xh018/cadence/v8_0/spectre/v8_0_1/lpmos/photo.scs" section=tm
include "/pkg/xfab/XKIT/xh018/cadence/v8_0/spectre/v8_0_1/lpmos/res.scs" section=tm

// MultiChannel_EMG_IMP/TCA_DSL_v2/schematic
V3 (net061 0) vsource dc=900m type=dc
V2 (VCM 0) vsource dc=900m type=dc
V5 (net36 VCM) vsource dc=VOS type=dc
V4 (VDDA 0) vsource dc=1.8 type=dc
M27 (net065 net084 VDDA VDDA) pe w=2u l=2u m=(1)*(20)
M26 (net084 net084 VDDA VDDA) pe w=2u l=2u m=(1)*(20)
M25 (net080 net016 VDDA VDDA) pe w=2u l=2u m=(1)*(20)
M24 (net016 net016 VDDA VDDA) pe w=2u l=2u m=(1)*(20)
M23 (net080 outp VDDA VDDA) pe w=2u l=2u m=(1)*(20)
M22 (net065 outn VDDA VDDA) pe w=2u l=2u m=(1)*(20)
M17 (net030 net061 net029 net029) pe w=2u l=2u m=(1)*(20)
M8 (net028 net024 net029 net029) pe w=2u l=2u m=(1)*(20)
M5 (net026 outp VDDA VDDA) pe w=2u l=2u m=(1)*(4)
M4 (net023 outn VDDA VDDA) pe w=2u l=2u m=(1)*(4)
M0 (net12 outp VDDA VDDA) pe w=2u l=2u m=(1)*(20)
M1 (net10 Vinp net12 net12) pe w=10u l=500n m=(1)*(20)
M7 (outp outp VDDA VDDA) pe w=2u l=2u m=(1)*(20)
M6 (0 net10 net039 net039) pe w=8u l=180.0n m=(1)*(10)
M13 (net13 outn VDDA VDDA) pe w=2u l=2u m=(1)*(20)
M3 (net14 Vinn net13 net13) pe w=10u l=500n m=(1)*(20)
M12 (outn outn VDDA VDDA) pe w=2u l=2u m=(1)*(20)
M10 (0 net14 net17 net17) pe w=8u l=180.0n m=(1)*(10)
IPRB1 (outp net039) iprobe
IPRB0 (outn net17) iprobe
M29 (net065 net065 0 0) ne w=375.00n l=15.0u m=(1)*(20)
M28 (net080 net080 0 0) ne w=375.00n l=15.0u m=(1)*(20)
M19 (net084 net026 net018 0) ne w=375.00n l=15.0u m=(1)*(20)
M18 (net016 net023 net015 0) ne w=375.00n l=15.0u m=(1)*(20)
M16 (net030 net030 0 0) ne w=375.00n l=15.0u m=(1)*(20)
M14 (net028 net028 0 0) ne w=375.00n l=15.0u m=(1)*(20)
M11 (net026 net030 0 0) ne w=375.00n l=15.0u m=(1)*(20)
M9 (net023 net030 0 0) ne w=375.00n l=15.0u m=(1)*(20)
M20 (IBIAS2 IBIAS2 IBIAS 0) ne w=375.00n l=15.0u m=(1)*(20)
M21 (IBIAS IBIAS 0 0) ne w=375.00n l=15.0u m=(1)*(20)
M2 (net10 IBIAS 0 0) ne w=375.00n l=15.0u m=(1)*(20)
M15 (net14 IBIAS 0 0) ne w=375.00n l=15.0u m=(1)*(20)
R4 (net015 net018) resistor r=0.90M
R3 (0 net062) resistor r=0
R2 (net024 net023) resistor r=1M
R1 (net026 net024) resistor r=1M
R0 (net12 net13) resistor r=10K
V0 (Vinp net36) vsource mag=500.0m type=sine ampl=AMP_input freq=freq_input
V1 (VCM Vinn) vsource mag=500.0m type=sine ampl=AMP_input freq=freq_input
I7 (net018 0) isource dc=200.0n type=dc
I5 (net015 0) isource dc=200.0n type=dc
I0 (VDDA net029) isource dc=800.0n type=dc
I1 (VDDA IBIAS2) isource dc=2u type=dc
C1 (net024 net062) capacitor c=1p
C0 (net026 net023) capacitor c=1n
simulatorOptions options reltol=100e-6 temp=27 homotopy=all limit=delta compatible=spice2
dcOp dc
ac ac start=0.01 stop=100k dec=20
save IPRB1:in M28:1
