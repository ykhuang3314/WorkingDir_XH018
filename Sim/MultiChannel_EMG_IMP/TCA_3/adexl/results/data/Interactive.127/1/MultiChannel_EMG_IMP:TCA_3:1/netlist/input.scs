// Design: MultiChannel_EMG_IMP/TCA_3
simulator lang=spectre
global 0
parameters CM_DC=0.9 Amp_input=500u Freq_input=500 Vos=50m
include "/pkg/xfab/XKIT/xh018/cadence/v8_0/spectre/v8_0_1/lpmos/config.scs" section=default
include "/pkg/xfab/XKIT/xh018/cadence/v8_0/spectre/v8_0_1/lpmos/param.scs" section=3s
include "/pkg/xfab/XKIT/xh018/cadence/v8_0/spectre/v8_0_1/lpmos/bip.scs" section=tm
include "/pkg/xfab/XKIT/xh018/cadence/v8_0/spectre/v8_0_1/lpmos/cap.scs" section=tm
include "/pkg/xfab/XKIT/xh018/cadence/v8_0/spectre/v8_0_1/lpmos/dio.scs" section=tm
include "/pkg/xfab/XKIT/xh018/cadence/v8_0/spectre/v8_0_1/lpmos/mos.scs" section=tm
include "/pkg/xfab/XKIT/xh018/cadence/v8_0/spectre/v8_0_1/lpmos/photo.scs" section=tm
include "/pkg/xfab/XKIT/xh018/cadence/v8_0/spectre/v8_0_1/lpmos/res.scs" section=tm

// MultiChannel_EMG_IMP/PseudoResistor_10GOhm/schematic
subckt PseudoResistor_10GOhm A B
    M7 (net8 net8 B net8) pel w=6u l=1u m=(1)*(4)
    M6 (net9 net9 A net9) pel w=6u l=1u m=(1)*(4)
    M5 (net7 net7 net9 net9) pel w=6u l=1u m=(1)*(1)
    M4 (net7 net7 net8 net8) pel w=6u l=1u m=(1)*(1)
ends PseudoResistor_10GOhm

// MultiChannel_EMG_IMP/TCA_3/schematic
M24 (net025 LPFoutn net073 net073) neli w=20u l=500n m=(1)*(2)
M23 (net067 LPFoutp net062 net062) neli w=20u l=500n m=(1)*(2)
M9 (VDDA VSn net036 net036) neli w=4u l=1u m=(1)*(10)
M8 (VDDA VSp net020 net020) neli w=4u l=1u m=(1)*(10)
V6 (net029 VCM) vsource dc=Vos type=dc
V2 (VCM 0) vsource dc=CM_DC type=dc
V4 (VDDA 0) vsource dc=1.8 type=dc
I24 (VDDA net06) isource dc=50n type=dc
C8 (net06 0) cmm5t area=4.85e-10 perimeter=88.5u m=10 par1=(10)
C7 (net019 0) cmm5t area=4.85e-10 perimeter=88.5u m=10 par1=(10)
C6 (net025 0) cmm5t area=4.85e-10 perimeter=88.5u m=10 par1=(10)
C5 (net067 0) cmm5t area=4.85e-10 perimeter=88.5u m=10 par1=(10)
C4 (net061 0) cmm5t area=4.85e-10 perimeter=88.5u m=10 par1=(10)
C2 (LPFoutp LPFoutn) cmm5t area=2.883e-10 perimeter=68.83u m=10 par1=(10)
C1 (net04 0) cmm5t area=4.85e-10 perimeter=88.5u m=10 par1=(10)
V1 (VCM Vinn) vsource mag=500.0m type=sine ampl=Amp_input/2 freq=Freq_input
V0 (Vinp net029) vsource mag=500.0m type=sine ampl=Amp_input/2 freq=Freq_input
M46 (net025 net019 VDDA VDDA) pel w=2u l=10u m=(1)*(1)
M45 (net067 net019 VDDA VDDA) pel w=2u l=10u m=(1)*(1)
M42 (net015 net015 net079 net079) pel w=10u l=500n m=(1)*(1)
M41 (net8 net8 net054 net054) pel w=10u l=500n m=(1)*(1)
M39 (net017 net013 net018 net018) pel w=2u l=10u m=(1)*(10)
M38 (net013 net013 net019 net019) pel w=2u l=10u m=(1)*(1)
M34 (net018 net019 VDDA VDDA) pel w=2u l=10u m=(1)*(10)
M33 (net019 net019 VDDA VDDA) pel w=2u l=10u m=(1)*(1)
M28 (net073 net025 VDDA VDDA) pel w=5u l=10u m=(1)*(1)
M27 (net062 net067 VDDA VDDA) pel w=5u l=10u m=(1)*(1)
M4 (net09 net09 VDDA VDDA) pel w=500n l=2u m=(1)*(5)
M3 (net13 net13 VDDA VDDA) pel w=500n l=2u m=(1)*(5)
M11 (net35 Vinn VSn VSn) pel w=20u l=500n m=(1)*(10)
M10 (0 net35 net015 net015) pel w=5u l=350.0n m=(1)*(10)
M31 (VSn net025 VDDA VDDA) pel w=5u l=10u m=(1)*(20)
M0 (VSp net09 VDDA VDDA) pel w=500n l=2u m=(1)*(10)
M6 (0 net36 net8 net8) pel w=5u l=350.0n m=(1)*(10)
M30 (VSp net067 VDDA VDDA) pel w=5u l=10u m=(1)*(20)
M5 (VSn net13 VDDA VDDA) pel w=500n l=2u m=(1)*(10)
M1 (net36 Vinp VSp VSp) pel w=20u l=500n m=(1)*(10)
IPRB0 (net13 net079) iprobe
IPRB1 (net09 net054) iprobe
M48 (net062 net04 0 0) nel w=1u l=15.0u m=(1)*(5)
M47 (net073 net04 0 0) nel w=1u l=15.0u m=(1)*(5)
M44 (net020 net04 0 0) nel w=1u l=15.0u m=(1)*(2)
M43 (net036 net04 0 0) nel w=1u l=15.0u m=(1)*(2)
M40 (net017 net017 net061 0) nel w=750.0n l=15.0u m=(1)*(2)
M37 (net013 net06 net069 0) nel w=1u l=15.0u m=(1)*(1)
M36 (net06 net06 net04 0) nel w=1u l=15.0u m=(1)*(1)
M35 (net061 net061 0 0) nel w=750.0n l=15.0u m=(1)*(2)
M32 (net069 net04 0 0) nel w=1u l=15.0u m=(1)*(1)
M29 (net04 net04 0 0) nel w=1u l=15.0u m=(1)*(1)
M15 (net35 net061 0 0) nel w=750.0n l=15.0u m=(1)*(24)
M2 (net36 net061 0 0) nel w=750.0n l=15.0u m=(1)*(24)
I26 (LPFoutn net036) PseudoResistor_10GOhm
I25 (net020 LPFoutp) PseudoResistor_10GOhm
R1 (net062 net073) rpp1k1 l=1.00528m w=2u m=1 par1=(1)
R0 (VSp VSn) rpp1k1 l=50.56u w=2u m=1 par1=(1)
simulatorOptions options reltol=100e-6 temp=27 homotopy=all limit=delta compatible=spice2
dcOp dc
noise noise start=1 stop=100M dec=20 oprobe=IPRB1 iprobe=V0
save IPRB1:in IPRB0:in M30:1 M31:1
