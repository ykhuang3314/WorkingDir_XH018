// Design: MultiChannel_EMG_IMP/TCA_3
simulator lang=spectre
global 0
parameters Amp_input=100u Freq_input=500 Vos=0
include "/pkg/xfab/XKIT/xh018/cadence/v8_0/spectre/v8_0_1/lpmos/config.scs" section=default
include "/pkg/xfab/XKIT/xh018/cadence/v8_0/spectre/v8_0_1/lpmos/param.scs" section=3s
include "/pkg/xfab/XKIT/xh018/cadence/v8_0/spectre/v8_0_1/lpmos/bip.scs" section=tm
include "/pkg/xfab/XKIT/xh018/cadence/v8_0/spectre/v8_0_1/lpmos/cap.scs" section=tm
include "/pkg/xfab/XKIT/xh018/cadence/v8_0/spectre/v8_0_1/lpmos/dio.scs" section=tm
include "/pkg/xfab/XKIT/xh018/cadence/v8_0/spectre/v8_0_1/lpmos/mos.scs" section=tm
include "/pkg/xfab/XKIT/xh018/cadence/v8_0/spectre/v8_0_1/lpmos/photo.scs" section=tm
include "/pkg/xfab/XKIT/xh018/cadence/v8_0/spectre/v8_0_1/lpmos/res.scs" section=tm

// MultiChannel_EMG_IMP/TCA_3/schematic
V6 (net029 VCM) vsource dc=Vos type=dc
V2 (VCM 0) vsource dc=900m type=dc
V4 (VDDA 0) vsource dc=1.8 type=dc
I9 (VDDA net25) isource dc=2u type=dc
I8 (VDDA net10) isource dc=2u type=dc
I1 (VDDA IBIAS) isource dc=5u type=dc
R0 (net10 net25) resistor r=20K
V1 (VCM Vinn) vsource mag=500.0m type=sine ampl=Amp_input/2 freq=Freq_input
V0 (Vinp net029) vsource mag=500.0m type=sine ampl=Amp_input/2 freq=Freq_input
M10 (0 net35 net015 net015) pel w=5u l=350.0n m=(1)*(10)
M6 (0 net36 net8 net8) pel w=5u l=350.0n m=(1)*(10)
M5 (net25 net13 VDDA VDDA) pel w=220.0n l=2.5u m=(1)*(10)
M4 (net09 net09 VDDA VDDA) pel w=220.0n l=2.5u m=(1)*(2)
M3 (net13 net13 VDDA VDDA) pel w=220.0n l=2.5u m=(1)*(2)
M0 (net10 net09 VDDA VDDA) pel w=220.0n l=2.5u m=(1)*(10)
M11 (net35 Vinn net25 net25) pel w=20u l=500n m=(1)*(10)
M1 (net36 Vinp net10 net10) pel w=20u l=500n m=(1)*(10)
IPRB0 (net13 net015) iprobe
IPRB1 (net09 net8) iprobe
M7 (IBIAS IBIAS 0 0) nel w=500n l=15.0u m=(1)*(10)
M15 (net35 IBIAS 0 0) nel w=500n l=15.0u m=(1)*(10)
M2 (net36 IBIAS 0 0) nel w=500n l=15.0u m=(1)*(10)
simulatorOptions options reltol=100e-6 temp=27 homotopy=all limit=delta compatible=spice2
dcOp dc
ac ac start=1 stop=100M dec=20
noise noise start=1 stop=100M dec=20 oprobe=IPRB1 iprobe=V0
save IPRB1:in IPRB0:in
