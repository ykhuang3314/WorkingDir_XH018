// Design: MultiChannel_EMG_IMP/TCA_DSL_v2
simulator lang=spectre
global 0
parameters AMP_input=100u freq_input=500 VOS=0
include "/pkg/xfab/XKIT/xh018/cadence/v8_0/spectre/v8_0_1/lpmos/config.scs" section=default
include "/pkg/xfab/XKIT/xh018/cadence/v8_0/spectre/v8_0_1/lpmos/param.scs" section=3s
include "/pkg/xfab/XKIT/xh018/cadence/v8_0/spectre/v8_0_1/lpmos/bip.scs" section=tm
include "/pkg/xfab/XKIT/xh018/cadence/v8_0/spectre/v8_0_1/lpmos/cap.scs" section=tm
include "/pkg/xfab/XKIT/xh018/cadence/v8_0/spectre/v8_0_1/lpmos/dio.scs" section=tm
include "/pkg/xfab/XKIT/xh018/cadence/v8_0/spectre/v8_0_1/lpmos/mos.scs" section=tm
include "/pkg/xfab/XKIT/xh018/cadence/v8_0/spectre/v8_0_1/lpmos/photo.scs" section=tm
include "/pkg/xfab/XKIT/xh018/cadence/v8_0/spectre/v8_0_1/lpmos/res.scs" section=tm

// MultiChannel_EMG_IMP/TCA_DSL_v2/schematic
V2 (VCM 0) vsource dc=900m type=dc
V5 (net36 VCM) vsource dc=VOS type=dc
V4 (VDDA 0) vsource dc=1.8 type=dc
M55 (net12 VDDA VDDA VDDA) pe w=4u l=10u m=(3)*(2)
M54 (net13 VDDA VDDA VDDA) pe w=4u l=10u m=(3)*(2)
M0 (net12 outp VDDA VDDA) pe w=2u l=2u m=(1)*(20)
M1 (net10 Vinp net12 net12) pe w=10u l=500n m=(1)*(20)
M7 (outp outp VDDA VDDA) pe w=2u l=2u m=(1)*(20)
M6 (0 net10 net24 net24) pe w=8u l=180.0n m=(1)*(10)
M13 (net13 outn VDDA VDDA) pe w=2u l=2u m=(1)*(20)
M3 (net14 Vinn net13 net13) pe w=10u l=500n m=(1)*(20)
M12 (outn outn VDDA VDDA) pe w=2u l=2u m=(1)*(20)
M10 (0 net14 net17 net17) pe w=8u l=180.0n m=(1)*(10)
IPRB1 (outp net24) iprobe
IPRB0 (outn net17) iprobe
M20 (IBIAS2 IBIAS2 IBIAS 0) ne w=375.00n l=15.0u m=(1)*(20)
M21 (IBIAS IBIAS 0 0) ne w=375.00n l=15.0u m=(1)*(20)
M2 (net10 IBIAS 0 0) ne w=375.00n l=15.0u m=(1)*(20)
M15 (net14 IBIAS 0 0) ne w=375.00n l=15.0u m=(1)*(20)
R0 (net12 net13) resistor r=10K
V0 (Vinp net36) vsource mag=500.0m type=sine ampl=AMP_input freq=freq_input
V1 (VCM Vinn) vsource mag=500.0m type=sine ampl=AMP_input freq=freq_input
I1 (VDDA IBIAS2) isource dc=2u type=dc
simulatorOptions options reltol=100e-6 temp=27 homotopy=all limit=delta compatible=spice2
dcOp dc
ac ac start=0.1 stop=100k dec=10
save IPRB1:in
