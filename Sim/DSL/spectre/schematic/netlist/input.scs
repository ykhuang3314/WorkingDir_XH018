// Design: MultiChannel_EMG_Model/DSL
simulator lang=spectre
global 0
parameters Rint=16G
include "/pkg/xfab/XKIT/xh018/cadence/v8_0/spectre/v8_0_1/lpmos/config.scs" section=default
include "/pkg/xfab/XKIT/xh018/cadence/v8_0/spectre/v8_0_1/lpmos/param.scs" section=3s
include "/pkg/xfab/XKIT/xh018/cadence/v8_0/spectre/v8_0_1/lpmos/bip.scs" section=tm
include "/pkg/xfab/XKIT/xh018/cadence/v8_0/spectre/v8_0_1/lpmos/cap.scs" section=tm
include "/pkg/xfab/XKIT/xh018/cadence/v8_0/spectre/v8_0_1/lpmos/dio.scs" section=tm
include "/pkg/xfab/XKIT/xh018/cadence/v8_0/spectre/v8_0_1/lpmos/mos.scs" section=tm
include "/pkg/xfab/XKIT/xh018/cadence/v8_0/spectre/v8_0_1/lpmos/photo.scs" section=tm
include "/pkg/xfab/XKIT/xh018/cadence/v8_0/spectre/v8_0_1/lpmos/res.scs" section=tm

// MultiChannel_EMG_Model/DSL/schematic
M1 (net066 n1 net024 0) ne w=2u l=500n m=(1)*(30)
M0 (net062 net012 net028 0) ne w=2u l=500n m=(1)*(30)
M31 (net012 net30 net27 0) ne w=10u l=20u m=(1)*(1)
M29 (n1 net25 net27 0) ne w=10u l=20u m=(1)*(1)
I3 (net028 0) isource dc=500n type=sine
I1 (net024 0) isource dc=500n type=sine
I36 (net28 0) isource dc=50n type=sine
I30 (net27 0) isource dc=100n type=sine
V9 (net57 0) vsource dc=1.1 mag=500m type=sine
V10 (net61 0) vsource dc=1.1 mag=-500m type=sine
R6 (net065 net028) resistor r=25K
R5 (net024 net065) resistor r=25K
R2 (net012 net30) resistor r=Rint
R1 (net30 net61) resistor r=Rint/20
R0 (net25 n1) resistor r=Rint
R10 (net57 net25) resistor r=Rint/20
M3 (net054 net054 VDDA VDDA) pe w=4u l=10u m=(1)*(2)
M2 (net029 net029 VDDA VDDA) pe w=4u l=10u m=(1)*(2)
M53 (net28 net28 VDDA VDDA) pe w=2u l=40u m=(1)*(1)
M52 (net012 net28 VDDA VDDA) pe w=2u l=40u m=(1)*(1)
M51 (n1 net28 VDDA VDDA) pe w=2u l=40u m=(1)*(1)
C9 (net012 net30) capacitor c=5p
C8 (n1 net25) capacitor c=10p
IPRB3 (net029 net062) iprobe
IPRB0 (net054 net066) iprobe
V4 (VDDA 0) vsource dc=1.8 type=dc
simulatorOptions options reltol=100e-6 temp=27 homotopy=all limit=delta compatible=spice2
ac ac start=1m stop=100K dec=20
dcOp dc
save IPRB0:in IPRB3:in
