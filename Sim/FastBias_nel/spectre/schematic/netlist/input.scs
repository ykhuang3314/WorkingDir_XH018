// Design: Device_Characteristics/FastBias_nel
simulator lang=spectre
global 0
parameters IDS6=1e-07 VDS6=0.5 WF6=3.75e-07 L6=1.5e-05 NF6=1 IDS5=1e-07 VDS5=0.5 WF5=3.75e-07 L5=1.5e-05 NF5=1 IDS4=5e-07 VDS4=0.5 WF4=2e-06 L4=1e-06 NF4=10 IDS3=5e-06 VDS3=0.3 WF3=5e-07 L3=1.5e-05 NF3=10 IDS2=5e-08 VDS2=0.5 WF2=2e-05 L2=1e-05 NF2=1 IDS1=5e-06 VDS1=0.5 WF1=5e-07 L1=1e-05 NF1=10
include "/pkg/xfab/XKIT/xh018/cadence/v8_0/spectre/v8_0_1/lpmos/config.scs" section=default
include "/pkg/xfab/XKIT/xh018/cadence/v8_0/spectre/v8_0_1/lpmos/param.scs" section=3s
include "/pkg/xfab/XKIT/xh018/cadence/v8_0/spectre/v8_0_1/lpmos/bip.scs" section=tm
include "/pkg/xfab/XKIT/xh018/cadence/v8_0/spectre/v8_0_1/lpmos/cap.scs" section=tm
include "/pkg/xfab/XKIT/xh018/cadence/v8_0/spectre/v8_0_1/lpmos/dio.scs" section=tm
include "/pkg/xfab/XKIT/xh018/cadence/v8_0/spectre/v8_0_1/lpmos/mos.scs" section=tm
include "/pkg/xfab/XKIT/xh018/cadence/v8_0/spectre/v8_0_1/lpmos/photo.scs" section=tm
include "/pkg/xfab/XKIT/xh018/cadence/v8_0/spectre/v8_0_1/lpmos/res.scs" section=tm

// Device_Characteristics/Bias_nel/schematic
subckt Bias_nel
parameters IDS VDS W L NF
    I0 (0 D) isource dc=IDS type=dc
    E0 (G 0 D net7) vcvs gain=1000
    V0 (net7 0) vsource dc=VDS type=dc
    M0 (D G 0 0) nel w=W l=L m=(1)*(NF)
ends Bias_nel

// Device_Characteristics/FastBias_nel/schematic
I5 Bias_nel IDS=IDS6 VDS=VDS6 W=WF6 L=L6 NF=NF6
I4 Bias_nel IDS=IDS5 VDS=VDS5 W=WF5 L=L5 NF=NF5
I3 Bias_nel IDS=IDS4 VDS=VDS4 W=WF4 L=L4 NF=NF4
I2 Bias_nel IDS=IDS3 VDS=VDS3 W=WF3 L=L3 NF=NF3
I1 Bias_nel IDS=IDS2 VDS=VDS2 W=WF2 L=L2 NF=NF2
I0 Bias_nel IDS=IDS1 VDS=VDS1 W=WF1 L=L1 NF=NF1
simulatorOptions options reltol=100e-6 temp=27 homotopy=all limit=delta compatible=spice2
dcOp dc
