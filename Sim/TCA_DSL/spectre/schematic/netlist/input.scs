// Design: MultiChannel_EMG_Model/TCA_DSL
simulator lang=spectre
global 0
parameters Rint=1000000000
include "/pkg/xfab/XKIT/xh018/cadence/v8_0/spectre/v8_0_1/lpmos/config.scs" section=default
include "/pkg/xfab/XKIT/xh018/cadence/v8_0/spectre/v8_0_1/lpmos/param.scs" section=3s
include "/pkg/xfab/XKIT/xh018/cadence/v8_0/spectre/v8_0_1/lpmos/bip.scs" section=tm
include "/pkg/xfab/XKIT/xh018/cadence/v8_0/spectre/v8_0_1/lpmos/cap.scs" section=tm
include "/pkg/xfab/XKIT/xh018/cadence/v8_0/spectre/v8_0_1/lpmos/dio.scs" section=tm
include "/pkg/xfab/XKIT/xh018/cadence/v8_0/spectre/v8_0_1/lpmos/mos.scs" section=tm
include "/pkg/xfab/XKIT/xh018/cadence/v8_0/spectre/v8_0_1/lpmos/photo.scs" section=tm
include "/pkg/xfab/XKIT/xh018/cadence/v8_0/spectre/v8_0_1/lpmos/res.scs" section=tm

// MultiChannel_EMG_Model/TCA_DSL/schematic
M31 (net098 net082 net090 0) ne w=10u l=20u m=(1)*(3)
M29 (net091 net092 net090 0) ne w=10u l=20u m=(1)*(1)
M27 (net087 inp_TCA net033 0) ne w=2u l=500n m=(1)*(30)
M28 (net036 inn_TCA net035 0) ne w=2u l=500n m=(1)*(30)
M20 (IBIAS2 IBIAS2 IBIAS 0) ne w=375.00n l=15.0u m=(1)*(20)
M21 (IBIAS IBIAS 0 0) ne w=375.00n l=15.0u m=(1)*(20)
M15 (net10 IBIAS 0 0) ne w=375.00n l=15.0u m=(1)*(20)
M2 (net8 IBIAS 0 0) ne w=375.00n l=15.0u m=(1)*(20)
V2 (VCM 0) vsource dc=900m type=dc
V4 (VDDA 0) vsource dc=1.8 type=dc
M53 (net043 net043 VDDA VDDA) pe w=2u l=40u m=(1)*(1)
M52 (net098 net043 VDDA VDDA) pe w=2u l=40u m=(1)*(1)
M51 (net091 net043 VDDA VDDA) pe w=2u l=40u m=(1)*(1)
M38 (net069 net069 VDDA VDDA) pe w=4u l=10u m=(1)*(2)
M37 (net036 net036 VDDA VDDA) pe w=4u l=10u m=(1)*(2)
M48 (net057 net029 VDDA VDDA) pe w=2u l=2u m=(1)*(1)
M43 (net079 net079 net029 net029) pe w=4u l=2u m=(1)*(20)
M34 (net029 net029 VDDA VDDA) pe w=2u l=2u m=(1)*(1)
M47 (outn_TIA net079 net057 net057) pe w=4u l=2u m=(1)*(20)
M42 (net037 inn_TCA net072 net072) pe w=4u l=3u m=(1)*(20)
M41 (net088 net088 VDDA VDDA) pe w=5u l=10u m=(1)*(6)
M40 (net072 net072 VDDA VDDA) pe w=5u l=10u m=(1)*(6)
M39 (net037 inp_TCA net068 net068) pe w=4u l=3u m=(1)*(20)
M44 (outp_TIA net075 net074 net074) pe w=4u l=2u m=(1)*(20)
M46 (net075 net075 net023 net023) pe w=4u l=2u m=(1)*(20)
M30 (net023 net023 VDDA VDDA) pe w=2u l=2u m=(1)*(1)
M45 (net074 net023 VDDA VDDA) pe w=2u l=2u m=(1)*(1)
M0 (net9 outp VDDA VDDA) pe w=2u l=2u m=(1)*(20)
M7 (outp outp VDDA VDDA) pe w=2u l=2u m=(1)*(20)
M13 (net24 outn VDDA VDDA) pe w=2u l=2u m=(1)*(20)
M12 (outn outn VDDA VDDA) pe w=2u l=2u m=(1)*(20)
M1 (net8 Vinp net9 net9) pe w=10u l=500n m=(1)*(20)
M3 (net10 Vinn net24 net24) pe w=10u l=500n m=(1)*(20)
M6 (0 net8 net19 net19) pe w=8u l=180.0n m=(1)*(10)
M10 (0 net10 net13 net13) pe w=8u l=180.0n m=(1)*(10)
I1 (VDDA IBIAS2) isource dc=2u type=dc
V10 (net078 0) vsource dc=1.1 mag=-500m type=sine
V9 (net077 0) vsource dc=1.1 mag=500m type=sine
V8 (inn_TCA 0) vsource dc=900m mag=-500m type=sine
V7 (inp_TCA 0) vsource dc=900m mag=500m type=sine
V1 (VCM Vinn) vsource mag=500.0m type=sine
V0 (Vinp VCM) vsource mag=500.0m type=sine
IPRB2 (net069 net087) iprobe
IPRB3 (net088 net068) iprobe
IPRB1 (outp net19) iprobe
IPRB0 (outn net13) iprobe
R1 (net9 net24) rpp1k1 l=20.09u w=2u m=1 par1=(1)
C9 (net098 net082) capacitor c=5p
C8 (net091 net092) capacitor c=5p
C7 (outn_TIA outp_TIA) capacitor c=5p
R11 (net082 net078) resistor r=Rint
R10 (net077 net092) resistor r=Rint
R8 (net033 net035) resistor r=50K
R4 (outp_TIA outn_TIA) resistor r=Rint
R9 (net068 net072) resistor r=200K
I36 (net043 0) isource dc=50n type=sine
I30 (net090 0) isource dc=100n type=sine
I20 (net035 0) isource dc=500n type=sine
I15 (outn_TIA 0) isource dc=100n type=sine
I13 (0 net079) isource dc=-100n mag=500.0m type=sine
I19 (net033 0) isource dc=500n type=sine
I26 (net037 0) isource dc=1u type=sine
I11 (outp_TIA 0) isource dc=100n type=sine
I9 (net075 0) isource dc=100n mag=500.0m type=sine
simulatorOptions options reltol=100e-6 temp=27.0 homotopy=all limit=delta compatible=spice2
dcOp dc
ac ac start=1 stop=1M dec=20
