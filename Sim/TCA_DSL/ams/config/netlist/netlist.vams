// AMS netlist generated by the AMS Unified netlister
// IC subversion:  IC6.1.8-64b.500.7
// Xcelium version: 18.03-s018
// Copyright(C) 2005-2009, Cadence Design Systems, Inc
// User: ykhuang Pid: 10203
// Design library name: MultiChannel_EMG_Model
// Design cell name: TCA_DSL
// Design view name: config
// Solver: Spectre

`include "disciplines.vams"
`include "userDisciplines.vams"
// HDL file - MultiChannel_EMG_Model, LPF_FrontEnd, verilogams.
// Library - MultiChannel_EMG_Model, Cell - TCA_DSL, View - schematic
// LAST TIME SAVED: Oct  1 10:18:17 2021
// NETLIST TIME: Oct  1 10:18:26 2021

`worklib MultiChannel_EMG_Model
`view schematic

`timescale 1ns / 1ps
(* cds_ams_schematic *)

module TCA_DSL ( );
wire outn;
wire LPFoutn;
wire VDDA;
wire outp;
wire VCM;
wire LPFoutp;
LPF_FrontEnd #(.w(6.28319), .fc(1), .Gain(100)) I38 (.Voutp( LPFoutp ), .VCM( VCM ), .Vinp( outp ), .VDDA( VDDA ), .VSSA(cds_globals.\gnd! ), .Voutn( LPFoutn ), .Vinn( outn ));
ne #(.w(2e-06), .l(5e-07), .as(5.68e-13), .ad(5.4e-13), .ps(2.70133e-06), .pd(2.54e-06), .nrs(0.135), .nrd(0.135), .m((1)*(30)), .par1((1)*(30)), .xf_subext(0))
(* integer passed_mfactor = "m"; *)
 M27 (net045, LPFoutp, net020, cds_globals.\gnd! );
ne #(.w(2e-06), .l(5e-07), .as(5.68e-13), .ad(5.4e-13), .ps(2.70133e-06), .pd(2.54e-06), .nrs(0.135), .nrd(0.135), .m((1)*(30)), .par1((1)*(30)), .xf_subext(0))
(* integer passed_mfactor = "m"; *)
 M28 (n2, LPFoutn, net024, cds_globals.\gnd! );
ne #(.w(3.75e-07), .l(1.5e-05), .as(1.09125e-13), .ad(1.0125e-13), .ps(9.945e-07), .pd(9.15e-07), .nrs(0.72), .nrd(0.72), .m((1)*(20)), .par1((1)*(20)), .xf_subext(0))
(* integer passed_mfactor = "m"; *)
 M20 (IBIAS2, IBIAS2, IBIAS, cds_globals.\gnd! );
ne #(.w(3.75e-07), .l(1.5e-05), .as(1.09125e-13), .ad(1.0125e-13), .ps(9.945e-07), .pd(9.15e-07), .nrs(0.72), .nrd(0.72), .m((1)*(20)), .par1((1)*(20)), .xf_subext(0))
(* integer passed_mfactor = "m"; *)
 M21 (IBIAS, IBIAS, cds_globals.\gnd! , cds_globals.\gnd! );
ne #(.w(3.75e-07), .l(1.5e-05), .as(1.09125e-13), .ad(1.0125e-13), .ps(9.945e-07), .pd(9.15e-07), .nrs(0.72), .nrd(0.72), .m((1)*(20)), .par1((1)*(20)), .xf_subext(0))
(* integer passed_mfactor = "m"; *)
 M15 (net10, IBIAS, cds_globals.\gnd! , cds_globals.\gnd! );
ne #(.w(3.75e-07), .l(1.5e-05), .as(1.09125e-13), .ad(1.0125e-13), .ps(9.945e-07), .pd(9.15e-07), .nrs(0.72), .nrd(0.72), .m((1)*(20)), .par1((1)*(20)), .xf_subext(0))
(* integer passed_mfactor = "m"; *)
 M2 (net8, IBIAS, cds_globals.\gnd! , cds_globals.\gnd! );
vsource #(.dc(cds_globals.VOS), .type("dc")) V5 (net052, VCM);
vsource #(.dc(0.9), .type("dc")) V2 (VCM, cds_globals.\gnd! );
vsource #(.dc(1.8), .type("dc")) V4 (VDDA, cds_globals.\gnd! );
pe #(.w(4e-06), .l(1e-05), .as(1.92e-12), .ad(1.08e-12), .ps(8.96e-06), .pd(4.54e-06), .nrs(0.0675), .nrd(0.0675), .m((3)*(2)), .par1((3)*(2)))
(* integer passed_mfactor = "m"; *)
 M55 (net049, n1, VDDA, VDDA);
pe #(.w(4e-06), .l(1e-05), .as(1.92e-12), .ad(1.08e-12), .ps(8.96e-06), .pd(4.54e-06), .nrs(0.0675), .nrd(0.0675), .m((3)*(2)), .par1((3)*(2)))
(* integer passed_mfactor = "m"; *)
 M54 (net054, n2, VDDA, VDDA);
pe #(.w(4e-06), .l(1e-05), .as(1.92e-12), .ad(1.08e-12), .ps(8.96e-06), .pd(4.54e-06), .nrs(0.0675), .nrd(0.0675), .m((1)*(2)), .par1((1)*(2)))
(* integer passed_mfactor = "m"; *)
 M38 (n1, n1, VDDA, VDDA);
pe #(.w(4e-06), .l(1e-05), .as(1.92e-12), .ad(1.08e-12), .ps(8.96e-06), .pd(4.54e-06), .nrs(0.0675), .nrd(0.0675), .m((1)*(2)), .par1((1)*(2)))
(* integer passed_mfactor = "m"; *)
 M37 (n2, n2, VDDA, VDDA);
pe #(.w(2e-06), .l(2e-06), .as(5.82e-13), .ad(5.4e-13), .ps(2.782e-06), .pd(2.54e-06), .nrs(0.135), .nrd(0.135), .m((1)*(20)), .par1((1)*(20)))
(* integer passed_mfactor = "m"; *)
 M0 (net049, outp, VDDA, VDDA);
pe #(.w(2e-06), .l(2e-06), .as(5.82e-13), .ad(5.4e-13), .ps(2.782e-06), .pd(2.54e-06), .nrs(0.135), .nrd(0.135), .m((1)*(20)), .par1((1)*(20)))
(* integer passed_mfactor = "m"; *)
 M7 (outp, outp, VDDA, VDDA);
pe #(.w(2e-06), .l(2e-06), .as(5.82e-13), .ad(5.4e-13), .ps(2.782e-06), .pd(2.54e-06), .nrs(0.135), .nrd(0.135), .m((1)*(20)), .par1((1)*(20)))
(* integer passed_mfactor = "m"; *)
 M13 (net054, outn, VDDA, VDDA);
pe #(.w(2e-06), .l(2e-06), .as(5.82e-13), .ad(5.4e-13), .ps(2.782e-06), .pd(2.54e-06), .nrs(0.135), .nrd(0.135), .m((1)*(20)), .par1((1)*(20)))
(* integer passed_mfactor = "m"; *)
 M12 (outn, outn, VDDA, VDDA);
pe #(.w(1e-05), .l(5e-07), .as(2.91e-12), .ad(2.7e-12), .ps(1.1582e-05), .pd(1.054e-05), .nrs(0.027), .nrd(0.027), .m((1)*(20)), .par1((1)*(20)))
(* integer passed_mfactor = "m"; *)
 M1 (net8, Vinp, net049, net049);
pe #(.w(1e-05), .l(5e-07), .as(2.91e-12), .ad(2.7e-12), .ps(1.1582e-05), .pd(1.054e-05), .nrs(0.027), .nrd(0.027), .m((1)*(20)), .par1((1)*(20)))
(* integer passed_mfactor = "m"; *)
 M3 (net10, Vinn, net054, net054);
pe #(.w(8e-06), .l(1.8e-07), .as(2.496e-12), .ad(2.16e-12), .ps(1.0224e-05), .pd(8.54e-06), .nrs(0.03375), .nrd(0.03375), .m((1)*(10)), .par1((1)*(10)))
(* integer passed_mfactor = "m"; *)
 M6 (cds_globals.\gnd! , net8, net19, net19);
pe #(.w(8e-06), .l(1.8e-07), .as(2.496e-12), .ad(2.16e-12), .ps(1.0224e-05), .pd(8.54e-06), .nrs(0.03375), .nrd(0.03375), .m((1)*(10)), .par1((1)*(10)))
(* integer passed_mfactor = "m"; *)
 M10 (cds_globals.\gnd! , net10, net13, net13);
isource #(.dc(2e-06), .type("dc")) I1 (VDDA, IBIAS2);
vsource #(.mag(0.5), .type("sine")) V1 (VCM, Vinn);
vsource #(.mag(0.5), .type("sine")) V0 (Vinp, net052);
iprobe IPRB2 (n1, net045);
iprobe IPRB1 (outp, net19);
iprobe IPRB0 (outn, net13);
rpp1k1 #(.l(2.009e-05), .w(2e-06), .m(1), .par1(1))
(* integer passed_mfactor = "m"; *)
 R1 (net049, net054);
resistor #(.r(50000)) R8 (net020, net024);
isource #(.dc(5e-07), .type("sine")) I20 (net024, cds_globals.\gnd! );
isource #(.dc(5e-07), .type("sine")) I19 (net020, cds_globals.\gnd! );

endmodule
`noworklib
`noview
