// Design: Device_Characteristics/FastBias_pe
simulator lang=spectre
global 0
parameters WF6=3e-06 L6=5e-06 NF6=10 IDS6=5e-06 VDS6=1.0 WF5=2.5e-05 L5=3e-07 NF5=10 IDS5=5e-06 VDS5=0.3 WF4=1e-06 L4=1e-05 NF4=10 IDS4=1e-07 VDS4=0.5 WF3=5e-06 L3=1e-05 NF3=1 IDS3=1e-07 VDS3=0.5 WF2=4e-06 L2=1e-05 NF2=1 IDS2=5e-07 VDS2=0.5 WF1=2e-06 L1=4e-05 NF1=1 IDS1=5e-08 VDS1=0.5
include "/pkg/xfab/XKIT/xh018/cadence/v8_0/spectre/v8_0_1/lpmos/config.scs" section=default
include "/pkg/xfab/XKIT/xh018/cadence/v8_0/spectre/v8_0_1/lpmos/param.scs" section=3s
include "/pkg/xfab/XKIT/xh018/cadence/v8_0/spectre/v8_0_1/lpmos/bip.scs" section=tm
include "/pkg/xfab/XKIT/xh018/cadence/v8_0/spectre/v8_0_1/lpmos/cap.scs" section=tm
include "/pkg/xfab/XKIT/xh018/cadence/v8_0/spectre/v8_0_1/lpmos/dio.scs" section=tm
include "/pkg/xfab/XKIT/xh018/cadence/v8_0/spectre/v8_0_1/lpmos/mos.scs" section=tm
include "/pkg/xfab/XKIT/xh018/cadence/v8_0/spectre/v8_0_1/lpmos/photo.scs" section=tm
include "/pkg/xfab/XKIT/xh018/cadence/v8_0/spectre/v8_0_1/lpmos/res.scs" section=tm

// Device_Characteristics/Bias_pe/schematic
subckt Bias_pe
parameters WF L NF IDS VDS
    M0 (D G S S) pe w=WF l=L m=(1)*(NF)
    I0 (D S) isource dc=IDS type=dc
    E0 (S G net9 D) vcvs gain=1000
    V1 (S 0) vsource dc=1.8 type=dc
    V0 (S net9) vsource dc=VDS type=dc
ends Bias_pe

// Device_Characteristics/FastBias_pe/schematic
I5 Bias_pe WF=WF6 L=L6 NF=NF6 IDS=IDS6 VDS=VDS6
I4 Bias_pe WF=WF5 L=L5 NF=NF5 IDS=IDS5 VDS=VDS5
I3 Bias_pe WF=WF4 L=L4 NF=NF4 IDS=IDS4 VDS=VDS4
I2 Bias_pe WF=WF3 L=L3 NF=NF3 IDS=IDS3 VDS=VDS3
I1 Bias_pe WF=WF2 L=L2 NF=NF2 IDS=IDS2 VDS=VDS2
I0 Bias_pe WF=WF1 L=L1 NF=NF1 IDS=IDS1 VDS=VDS1
simulatorOptions options reltol=100e-6 temp=27 homotopy=all limit=delta compatible=spice2
dcOp dc
