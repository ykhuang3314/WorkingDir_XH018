ADE simulation setup
Run mode: Single Run, Sweeps and Corners
Tests:
  MultiChannel_EMG_IMP:TCA_DSL_v2:1: MultiChannel_EMG_IMP/TCA_DSL_v2/schematic, simulator spectre
Global variables:
  AMP_input = 100u
  freq_input = 500
  VOS = 50m
