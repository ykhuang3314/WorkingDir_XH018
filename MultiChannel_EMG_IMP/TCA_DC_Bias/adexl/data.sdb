ADE simulation setup
Run mode: Single Run, Sweeps and Corners
Tests:
  MultiChannel_EMG_IMP:TCA_DC_Bias:1: MultiChannel_EMG_IMP/TCA_DC_Bias/schematic, simulator spectre
