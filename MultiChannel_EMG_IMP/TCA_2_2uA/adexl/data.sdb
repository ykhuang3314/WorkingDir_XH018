ADE simulation setup
Run mode: Single Run, Sweeps and Corners
Tests:
  MultiChannel_EMG_IMP:TCA_2_2uA:1: MultiChannel_EMG_IMP/TCA_2_2uA/schematic, simulator spectre
    Outputs: AC_Mag; AC_Phase
