ADE simulation setup
Run mode: Single Run, Sweeps and Corners
Tests:
  MultiChannel_EMG_IMP:TCA_SmallSignal:1: MultiChannel_EMG_IMP/TCA_SmallSignal/schematic, simulator spectre
    Outputs: /IPRB1/PLUS
Global variables:
  gm1 = 113u
  IT = 0
  VIN = 1
