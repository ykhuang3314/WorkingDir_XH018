ADE simulation setup
Run mode: Single Run, Sweeps and Corners
Tests:
  MultiChannel_EMG_IMP:TCA_1:1: MultiChannel_EMG_IMP/TCA_1/schematic, simulator spectre
    Outputs: Input referred noise
Global variables:
  VIN_DC = 900m
