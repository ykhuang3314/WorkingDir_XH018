ADE simulation setup
Run mode: Single Run, Sweeps and Corners
Tests:
  MultiChannel_EMG_IMP:TCA_3:1: MultiChannel_EMG_IMP/TCA_3/schematic, simulator spectre
    Outputs: Iout_diff_ac_dB; input referred noise
Global variables:
  Amp_input = 500u
  Freq_input = 500
  Vos = 50m
  CM_DC = 0.9
