ADE simulation setup
Run mode: Single Run, Sweeps and Corners
Tests:
  MultiChannel_EMG_IMP:TCA_3:1: MultiChannel_EMG_IMP/TCA_3/schematic, simulator spectre
Global variables:
  Amp_input = 100u
  Freq_input = 500
  Vos = 0
