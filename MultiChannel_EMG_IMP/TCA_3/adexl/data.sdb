ADE simulation setup
Run mode: Single Run, Sweeps and Corners
Tests:
  MultiChannel_EMG_IMP:TCA_3:1: MultiChannel_EMG_IMP/TCA_3/schematic, simulator spectre
    Outputs: Iout_diff_ac_dB
Global variables:
  Amp_input = 100u
  Freq_input = 500
  Vos = {From/To}Auto:0:11:100m{From/To}
  CM_DC = 0.9
