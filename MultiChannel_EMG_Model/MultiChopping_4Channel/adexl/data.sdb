ADE simulation setup
Run mode: Single Run, Sweeps and Corners
Tests:
  MultiChannel_EMG_Model:MultiChopping_4Channel:1: MultiChannel_EMG_Model/MultiChopping_4Channel/config, simulator spectre
Global variables:
  fchop = 16k
  fin = 500
  Mag = 100u
  Vin_cm = 900m
  Voffset = 0
