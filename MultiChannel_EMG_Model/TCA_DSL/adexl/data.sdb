ADE simulation setup
Run mode: Single Run, Sweeps and Corners
Tests:
  MultiChannel_EMG_Model:TCA_DSL:1: MultiChannel_EMG_Model/TCA_DSL/config, simulator ams
Global variables:
  VOS = 20m
