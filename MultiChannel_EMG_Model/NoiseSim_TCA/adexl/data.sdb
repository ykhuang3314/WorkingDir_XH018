ADE simulation setup
Run mode: Single Run, Sweeps and Corners
Tests:
  MultiChannel_EMG_Model:NoiseSim_TCA:1: MultiChannel_EMG_Model/NoiseSim_TCA/schematic, simulator spectre
Global variables:
  IDS = 10u
  L = 500n
  NF = 25
  VDS = 0.5
  VGS = 0.503
  WF = 10u
  IDS_PMOS = 2.5u
  L_P = 500n
  NF_P = 10
  VDS_PMOS = 0.5
  VGS_PMOS = 0.59
  WF_P = 15u
