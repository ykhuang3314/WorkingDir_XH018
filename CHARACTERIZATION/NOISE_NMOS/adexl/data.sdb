ADE simulation setup
Run mode: Single Run, Sweeps and Corners
Tests:
  CHARACTERIZATION:NOISE_NMOS:1: CHARACTERIZATION/NOISE_NMOS/schematic, simulator spectre
  CHARACTERIZATION:NOISE_NMOS:2: CHARACTERIZATION/NOISE_NMOS/schematic, simulator spectre
  CHARACTERIZATION:NOISE_NMOS:3: CHARACTERIZATION/NOISE_NMOS/schematic, simulator spectre
Global variables:
  IDS = 10u
  L = 1u
  NF = 1
  VDS = 1
  WF = 10u
