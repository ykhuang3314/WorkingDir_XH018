ADE simulation setup
Run mode: Single Run, Sweeps and Corners
Tests:
  Device_Characteristics:Noise_ne:1: Device_Characteristics/Noise_ne/schematic, simulator spectre
  Device_Characteristics:Noise_ne:2 (off): Device_Characteristics/Noise_ne/schematic, simulator spectre
Global variables:
  IDS = 10u
  L = 0.5u
  NF = 40
  VDS = 0.5
  WF = 10u
