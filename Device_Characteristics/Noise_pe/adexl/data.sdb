ADE simulation setup
Run mode: Single Run, Sweeps and Corners
Tests:
  Device_Characteristics:Noise_pe:1: Device_Characteristics/Noise_pe/schematic, simulator spectre
Global variables:
  IDS = 5u
  L = 180n
  NF = 20
  VDS = 0.5
  WF = 10u
