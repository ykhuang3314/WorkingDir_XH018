ADE simulation setup
Run mode: Single Run, Sweeps and Corners
Tests:
  Device_Characteristics:DC_Bias_ne:1: Device_Characteristics/DC_Bias_ne/schematic, simulator spectre
Global variables:
  L = 500n
  NF = 40
  VDS = 500m
  VGS = 0.5
  W = 10u
