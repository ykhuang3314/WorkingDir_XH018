ADE simulation setup
Run mode: Single Run, Sweeps and Corners
Tests:
  Device_Characteristics:DC_Bias_pe:1 (off): Device_Characteristics/DC_Bias_pe/schematic, simulator spectre
  Device_Characteristics:DC_Bias_pe:2: Device_Characteristics/DC_Bias_pe/schematic, simulator spectre
Global variables:
  L = 0.5u
  NF = 40
  VDS = 0.5
  VGS = 500m
  WF = 10u
