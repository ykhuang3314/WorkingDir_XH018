;====================== Set to XL mode =========================================
ocnSetXLMode()
ocnxlProjectDir( "/home/saul/Sim/" )
ocnxlTargetCellView( "EXERCISE1" "S5_STATIC_LIN" "adexl" )
ocnxlResultsLocation( "" )
ocnxlSimResultsLocation( "" )
ocnxlMaxJobFail( 20 )

;====================== Tests setup ============================================

;---------- Test "EXERCISE1:S5_STATIC_LIN:1" -------------
ocnxlBeginTest("EXERCISE1:S5_STATIC_LIN:1")
simulator( 'spectre )
design( "EXERCISE1" "S5_STATIC_LIN" "schematic")
modelFile(
    '("/pkg/xfab/XKIT/xh018/cadence/v8_0/spectre/v8_0_1/lpmos/config.scs" "default")
    '("/pkg/xfab/XKIT/xh018/cadence/v8_0/spectre/v8_0_1/lpmos/param.scs" "3s")
    '("/pkg/xfab/XKIT/xh018/cadence/v8_0/spectre/v8_0_1/lpmos/bip.scs" "tm")
    '("/pkg/xfab/XKIT/xh018/cadence/v8_0/spectre/v8_0_1/lpmos/cap.scs" "tm")
    '("/pkg/xfab/XKIT/xh018/cadence/v8_0/spectre/v8_0_1/lpmos/dio.scs" "tm")
    '("/pkg/xfab/XKIT/xh018/cadence/v8_0/spectre/v8_0_1/lpmos/mos.scs" "tm")
    '("/pkg/xfab/XKIT/xh018/cadence/v8_0/spectre/v8_0_1/lpmos/photo.scs" "tm")
    '("/pkg/xfab/XKIT/xh018/cadence/v8_0/spectre/v8_0_1/lpmos/res.scs" "tm")
)
analysis('noise ?start "100"  ?stop "30M"  ?dec "10"
		?oprobe "/IPRB0"  ?iprobe "/I5"  )
analysis('pz ?p ""  ?n ""  ?oprobe "/IPRB0"
		?iprobe "/I5"  ?porti "1"  )
analysis('dc ?saveOppoint t  ?param "IS_DC"  ?start "-8u"
		?stop "8u"  ?step ".1u"  )
analysis('ac ?start "100"  ?stop "300M"  ?dec "10"  )
desVar(	  "IS_DC" 0	)
desVar(	  "R1" 100k	)
desVar(	  "R2" 400	)
desVar(	  "IS" 1	)
envOption(
	'firstRun  t
	'analysisOrder  list("dc" "ac" "pz" "noise" "dcmatch" "stb" "tran" "envlp" "lf" "xf" "sp" "pss" "pac" "pstb" "pnoise" "pxf" "psp" "qpss" "qpac" "qpnoise" "qpxf" "qpsp" "hb" "hbac" "hbstb" "hbnoise" "hbxf" "sens" "acmatch")
)
option( ?categ 'turboOpts
	'apsplus  t
	'uniMode  "APS"
)
save( 'i "/IPRB0/MINUS" )
temp( 27 )
ocnxlOutputTerminal( "/IPRB0/MINUS" ?plot t ?save t)
ocnxlOutputExpr( "getData(\"in\" ?result \"noise\")" ?name "input noise; A / sqrt(Hz)" ?plot t)
ocnxlOutputExpr( "pzFrequencyAndRealFilter(getData(\"zeros\" ?result \"pz\"))" ?name "Zeros" ?plot t)
ocnxlOutputExpr( "pzFrequencyAndRealFilter(getData(\"poles\" ?result \"pz\"))" ?name "Poles" ?plot t)
ocnxlOutputExpr( "deriv(IS(\"/IPRB0/MINUS\"))" ?plot t ?evalType 'point)
ocnxlEndTest() ; "EXERCISE1:S5_STATIC_LIN:1"

;====================== Sweeps setup ===========================================
ocnxlSweepVar("IS_DC" "0")
ocnxlSweepVar("R1" "100k")
ocnxlSweepVar("R2" "400")
ocnxlSweepVar("IS" "1")

;====================== Model Group setup ==========================================

;====================== Corners setup ==========================================

;====================== Checks and Asserts setup ============================================
ocnxlPutChecksAsserts(?netlist nil)

;====================== Job setup ==============================================
ocnxlJobSetup( '(
	"blockemail" "1"
	"configuretimeout" "300"
	"distributionmethod" "Local"
	"jobruntype" "ICRP"
	"estimatememoryvalue" ""
	"lingertimeout" "300"
	"maxjobs" "1"
	"name" "ADE XL Default"
	"preemptivestart" "1"
	"reconfigureimmediately" "1"
	"runtimeout" "-1"
	"showerrorwhenretrying" "1"
	"showoutputlogerror" "0"
	"startmaxjobsimmed" "1"
	"starttimeout" "300"
	"usesameprocess" "1"
) )

;====================== Disabled items =========================================

;====================== Run Mode Options ======================================

;====================== Starting Point Info ======================================

;====================== Run command ============================================
ocnxlRun( ?mode 'sweepsAndCorners ?nominalCornerEnabled t ?allCornersEnabled t ?allSweepsEnabled t)
ocnxlOutputSummary(?exprSummary t ?specSummary t ?detailed t ?wave t)
ocnxlOpenResults()

;====================== End XL Mode command ===================================
ocnxlEndXLMode()
