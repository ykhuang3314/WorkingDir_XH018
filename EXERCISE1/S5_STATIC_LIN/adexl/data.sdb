ADE simulation setup
Run mode: Single Run, Sweeps and Corners
Tests:
  EXERCISE1:S5_STATIC_LIN:1: EXERCISE1/S5_STATIC_LIN/schematic, simulator spectre
    Outputs: deriv(IS("/IPRB0/MINUS"))
Global variables:
  IS_DC = 0
  R1 = 100k
  R2 = 400
  IS = 1
