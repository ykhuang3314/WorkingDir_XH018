ADE simulation setup
Run mode: Single Run, Sweeps and Corners
Tests:
  Stimulator_TestBench:TB_ChannelSelection_imp:1: Stimulator_TestBench/TB_ChannelSelection_imp/config, simulator ams
