ADE simulation setup
Run mode: Single Run, Sweeps and Corners
Tests:
  Stimulator_TestBench:TB_Compliance_voltage:1: Stimulator_TestBench/TB_Compliance_voltage/config, simulator ams
Global variables:
  Iref = 280u
  vout = 20
