ADE simulation setup
Run mode: Single Run, Sweeps and Corners
Tests:
  Stimulator_TestBench:TB_CurrentProgrammability_imp:1: Stimulator_TestBench/TB_CurrentProgrammability_imp/config, simulator ams
